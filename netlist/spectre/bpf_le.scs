// bpf_le - lumped-element equivalent (VACASK / Spectre)
// generated by snp2le
// EQUIVALENT CIRCUIT FOR VECTOR FITTED S-MATRIX
// Created using scikit-rf vectorFitting.py
//
//
// OSDI device modules - drop these if the PDK's VACASK common
// include already provides them (path: $PDK_ROOT/$PDK/libs.tech/vacask/osdi)
load "spice/resistor.osdi"
load "spice/capacitor.osdi"
model defmod_r sp_resistor
model defmod_c sp_capacitor
// NOTE: controlled/independent sources use native VACASK primitives;
//       verify vsource / vccs / cccs against your VACASK build.
subckt bpf_le(p1 p2)
  V1 (p1 s1) vsource dc=0
  R1 (s1 0) defmod_r r=50
  Gd1_1 (0 s1 p1 0) vccs gm=-0.01152203666
  Fd1_1 (0 s1) cccs probe=V1 gain=-0.5761018332
  Gr1_1_1 (0 s1 x1_a1 0) vccs gm=3.719249573e+11
  Gr2_re_1_1 (0 s1 x2_re_a1 0) vccs gm=4.479773701e+11
  Gr2_im_1_1 (0 s1 x2_im_a1 0) vccs gm=1.26654924e+12
  Gr3_re_1_1 (0 s1 x3_re_a1 0) vccs gm=1209398275
  Gr3_im_1_1 (0 s1 x3_im_a1 0) vccs gm=-1212419346
  Gr4_re_1_1 (0 s1 x4_re_a1 0) vccs gm=2594373893
  Gr4_im_1_1 (0 s1 x4_im_a1 0) vccs gm=-3607149157
  Gr5_re_1_1 (0 s1 x5_re_a1 0) vccs gm=854409556.3
  Gr5_im_1_1 (0 s1 x5_im_a1 0) vccs gm=-4096586271
  Gr6_re_1_1 (0 s1 x6_re_a1 0) vccs gm=2.91482275e+10
  Gr6_im_1_1 (0 s1 x6_im_a1 0) vccs gm=-2.484685163e+10
  Gr7_re_1_1 (0 s1 x7_re_a1 0) vccs gm=1.762314586e+10
  Gr7_im_1_1 (0 s1 x7_im_a1 0) vccs gm=4384342001
  Gd1_2 (0 s1 p2 0) vccs gm=6.593548549e-05
  Fd1_2 (0 s1) cccs probe=V2 gain=0.003296774274
  Gr1_1_2 (0 s1 x1_a2 0) vccs gm=-353051498.4
  Gr2_re_1_2 (0 s1 x2_re_a2 0) vccs gm=-3954194807
  Gr2_im_1_2 (0 s1 x2_im_a2 0) vccs gm=-4100348980
  Gr3_re_1_2 (0 s1 x3_re_a2 0) vccs gm=-1157835790
  Gr3_im_1_2 (0 s1 x3_im_a2 0) vccs gm=1240121831
  Gr4_re_1_2 (0 s1 x4_re_a2 0) vccs gm=2569352490
  Gr4_im_1_2 (0 s1 x4_im_a2 0) vccs gm=-3671471485
  Gr5_re_1_2 (0 s1 x5_re_a2 0) vccs gm=-787015744.1
  Gr5_im_1_2 (0 s1 x5_im_a2 0) vccs gm=4229918930
  Gr6_re_1_2 (0 s1 x6_re_a2 0) vccs gm=4969128554
  Gr6_im_1_2 (0 s1 x6_im_a2 0) vccs gm=1.192601989e+10
  Gr7_re_1_2 (0 s1 x7_re_a2 0) vccs gm=-5518740253
  Gr7_im_1_2 (0 s1 x7_im_a2 0) vccs gm=-1.353086241e+10
  Cx1_a1 (x1_a1 0) defmod_c c=0.002471715245
  Gx1_a1 (0 x1_a1 p1 0) vccs gm=0.0001747766611
  Fx1_a1 (0 x1_a1) cccs probe=V1 gain=0.008738833053
  Rp1_a1 (0 x1_a1) defmod_r r=1e-09
  Cx2_re_a1 (x2_re_a1 0) defmod_c c=0.000628342386
  Gx2_re_a1 (0 x2_re_a1 p1 0) vccs gm=8.886103241e-05
  Fx2_re_a1 (0 x2_re_a1) cccs probe=V1 gain=0.004443051621
  Rp2_re_re_a1 (0 x2_re_a1) defmod_r r=1e-09
  Gp2_re_im_a1 (0 x2_re_a1 x2_im_a1 0) vccs gm=1073225546
  Cx2_im_a1 (x2_im_a1 0) defmod_c c=0.000628342386
  Gp2_im_re_a1 (0 x2_im_a1 x2_re_a1 0) vccs gm=-1073225546
  Rp2_im_im_a1 (0 x2_im_a1) defmod_r r=1e-09
  Cx3_re_a1 (x3_re_a1 0) defmod_c c=0.03881034056
  Gx3_re_a1 (0 x3_re_a1 p1 0) vccs gm=0.005488610998
  Fx3_re_a1 (0 x3_re_a1) cccs probe=V1 gain=0.2744305499
  Rp3_re_re_a1 (0 x3_re_a1) defmod_r r=1e-09
  Gp3_re_im_a1 (0 x3_re_a1 x3_im_a1 0) vccs gm=3.592719925e+10
  Cx3_im_a1 (x3_im_a1 0) defmod_c c=0.03881034056
  Gp3_im_re_a1 (0 x3_im_a1 x3_re_a1 0) vccs gm=-3.592719925e+10
  Rp3_im_im_a1 (0 x3_im_a1) defmod_r r=1e-09
  Cx4_re_a1 (x4_re_a1 0) defmod_c c=0.02816494014
  Gx4_re_a1 (0 x4_re_a1 p1 0) vccs gm=0.003983124033
  Fx4_re_a1 (0 x4_re_a1) cccs probe=V1 gain=0.1991562017
  Rp4_re_re_a1 (0 x4_re_a1) defmod_r r=1e-09
  Gp4_re_im_a1 (0 x4_re_a1 x4_im_a1 0) vccs gm=2.788510804e+10
  Cx4_im_a1 (x4_im_a1 0) defmod_c c=0.02816494014
  Gp4_im_re_a1 (0 x4_im_a1 x4_re_a1 0) vccs gm=-2.788510804e+10
  Rp4_im_im_a1 (0 x4_im_a1) defmod_r r=1e-09
  Cx5_re_a1 (x5_re_a1 0) defmod_c c=0.02832231764
  Gx5_re_a1 (0 x5_re_a1 p1 0) vccs gm=0.004005380572
  Fx5_re_a1 (0 x5_re_a1) cccs probe=V1 gain=0.2002690286
  Rp5_re_re_a1 (0 x5_re_a1) defmod_r r=1e-09
  Gp5_re_im_a1 (0 x5_re_a1 x5_im_a1 0) vccs gm=3.026109416e+10
  Cx5_im_a1 (x5_im_a1 0) defmod_c c=0.02832231764
  Gp5_im_re_a1 (0 x5_im_a1 x5_re_a1 0) vccs gm=-3.026109416e+10
  Rp5_im_im_a1 (0 x5_im_a1) defmod_r r=1e-09
  Cx6_re_a1 (x6_re_a1 0) defmod_c c=0.01004943133
  Gx6_re_a1 (0 x6_re_a1 p1 0) vccs gm=0.001421204207
  Fx6_re_a1 (0 x6_re_a1) cccs probe=V1 gain=0.07106021037
  Rp6_re_re_a1 (0 x6_re_a1) defmod_r r=1e-09
  Gp6_re_im_a1 (0 x6_re_a1 x6_im_a1 0) vccs gm=1.189747778e+10
  Cx6_im_a1 (x6_im_a1 0) defmod_c c=0.01004943133
  Gp6_im_re_a1 (0 x6_im_a1 x6_re_a1 0) vccs gm=-1.189747778e+10
  Rp6_im_im_a1 (0 x6_im_a1) defmod_r r=1e-09
  Cx7_re_a1 (x7_re_a1 0) defmod_c c=0.01056929241
  Gx7_re_a1 (0 x7_re_a1 p1 0) vccs gm=0.001494723668
  Fx7_re_a1 (0 x7_re_a1) cccs probe=V1 gain=0.07473618339
  Rp7_re_re_a1 (0 x7_re_a1) defmod_r r=1e-09
  Gp7_re_im_a1 (0 x7_re_a1 x7_im_a1 0) vccs gm=1.242993984e+10
  Cx7_im_a1 (x7_im_a1 0) defmod_c c=0.01056929241
  Gp7_im_re_a1 (0 x7_im_a1 x7_re_a1 0) vccs gm=-1.242993984e+10
  Rp7_im_im_a1 (0 x7_im_a1) defmod_r r=1e-09
  V2 (p2 s2) vsource dc=0
  R2 (s2 0) defmod_r r=50
  Gd2_1 (0 s2 p1 0) vccs gm=6.593548542e-05
  Fd2_1 (0 s2) cccs probe=V1 gain=0.003296774271
  Gr1_2_1 (0 s2 x1_a1 0) vccs gm=-353051498.4
  Gr2_re_2_1 (0 s2 x2_re_a1 0) vccs gm=-3954194805
  Gr2_im_2_1 (0 s2 x2_im_a1 0) vccs gm=-4100348979
  Gr3_re_2_1 (0 s2 x3_re_a1 0) vccs gm=-1157835790
  Gr3_im_2_1 (0 s2 x3_im_a1 0) vccs gm=1240121831
  Gr4_re_2_1 (0 s2 x4_re_a1 0) vccs gm=2569352490
  Gr4_im_2_1 (0 s2 x4_im_a1 0) vccs gm=-3671471485
  Gr5_re_2_1 (0 s2 x5_re_a1 0) vccs gm=-787015744.2
  Gr5_im_2_1 (0 s2 x5_im_a1 0) vccs gm=4229918930
  Gr6_re_2_1 (0 s2 x6_re_a1 0) vccs gm=4969128554
  Gr6_im_2_1 (0 s2 x6_im_a1 0) vccs gm=1.192601989e+10
  Gr7_re_2_1 (0 s2 x7_re_a1 0) vccs gm=-5518740253
  Gr7_im_2_1 (0 s2 x7_im_a1 0) vccs gm=-1.353086241e+10
  Gd2_2 (0 s2 p2 0) vccs gm=-0.01149510096
  Fd2_2 (0 s2) cccs probe=V2 gain=-0.5747550482
  Gr1_2_2 (0 s2 x1_a2 0) vccs gm=3.719456765e+11
  Gr2_re_2_2 (0 s2 x2_re_a2 0) vccs gm=4.459888901e+11
  Gr2_im_2_2 (0 s2 x2_im_a2 0) vccs gm=1.265283808e+12
  Gr3_re_2_2 (0 s2 x3_re_a2 0) vccs gm=1206718781
  Gr3_im_2_2 (0 s2 x3_im_a2 0) vccs gm=-1220021643
  Gr4_re_2_2 (0 s2 x4_re_a2 0) vccs gm=2590805714
  Gr4_im_2_2 (0 s2 x4_im_a2 0) vccs gm=-3642619207
  Gr5_re_2_2 (0 s2 x5_re_a2 0) vccs gm=847746550
  Gr5_im_2_2 (0 s2 x5_im_a2 0) vccs gm=-4164045934
  Gr6_re_2_2 (0 s2 x6_re_a2 0) vccs gm=2.6172233e+10
  Gr6_im_2_2 (0 s2 x6_im_a2 0) vccs gm=-2.010089934e+10
  Gr7_re_2_2 (0 s2 x7_re_a2 0) vccs gm=2.084781176e+10
  Gr7_im_2_2 (0 s2 x7_im_a2 0) vccs gm=-151423645.6
  Cx1_a2 (x1_a2 0) defmod_c c=0.002471715245
  Gx1_a2 (0 x1_a2 p2 0) vccs gm=0.0001747766611
  Fx1_a2 (0 x1_a2) cccs probe=V2 gain=0.008738833053
  Rp1_a2 (0 x1_a2) defmod_r r=1e-09
  Cx2_re_a2 (x2_re_a2 0) defmod_c c=0.000628342386
  Gx2_re_a2 (0 x2_re_a2 p2 0) vccs gm=8.886103241e-05
  Fx2_re_a2 (0 x2_re_a2) cccs probe=V2 gain=0.004443051621
  Rp2_re_re_a2 (0 x2_re_a2) defmod_r r=1e-09
  Gp2_re_im_a2 (0 x2_re_a2 x2_im_a2 0) vccs gm=1073225546
  Cx2_im_a2 (x2_im_a2 0) defmod_c c=0.000628342386
  Gp2_im_re_a2 (0 x2_im_a2 x2_re_a2 0) vccs gm=-1073225546
  Rp2_im_im_a2 (0 x2_im_a2) defmod_r r=1e-09
  Cx3_re_a2 (x3_re_a2 0) defmod_c c=0.03881034056
  Gx3_re_a2 (0 x3_re_a2 p2 0) vccs gm=0.005488610998
  Fx3_re_a2 (0 x3_re_a2) cccs probe=V2 gain=0.2744305499
  Rp3_re_re_a2 (0 x3_re_a2) defmod_r r=1e-09
  Gp3_re_im_a2 (0 x3_re_a2 x3_im_a2 0) vccs gm=3.592719925e+10
  Cx3_im_a2 (x3_im_a2 0) defmod_c c=0.03881034056
  Gp3_im_re_a2 (0 x3_im_a2 x3_re_a2 0) vccs gm=-3.592719925e+10
  Rp3_im_im_a2 (0 x3_im_a2) defmod_r r=1e-09
  Cx4_re_a2 (x4_re_a2 0) defmod_c c=0.02816494014
  Gx4_re_a2 (0 x4_re_a2 p2 0) vccs gm=0.003983124033
  Fx4_re_a2 (0 x4_re_a2) cccs probe=V2 gain=0.1991562017
  Rp4_re_re_a2 (0 x4_re_a2) defmod_r r=1e-09
  Gp4_re_im_a2 (0 x4_re_a2 x4_im_a2 0) vccs gm=2.788510804e+10
  Cx4_im_a2 (x4_im_a2 0) defmod_c c=0.02816494014
  Gp4_im_re_a2 (0 x4_im_a2 x4_re_a2 0) vccs gm=-2.788510804e+10
  Rp4_im_im_a2 (0 x4_im_a2) defmod_r r=1e-09
  Cx5_re_a2 (x5_re_a2 0) defmod_c c=0.02832231764
  Gx5_re_a2 (0 x5_re_a2 p2 0) vccs gm=0.004005380572
  Fx5_re_a2 (0 x5_re_a2) cccs probe=V2 gain=0.2002690286
  Rp5_re_re_a2 (0 x5_re_a2) defmod_r r=1e-09
  Gp5_re_im_a2 (0 x5_re_a2 x5_im_a2 0) vccs gm=3.026109416e+10
  Cx5_im_a2 (x5_im_a2 0) defmod_c c=0.02832231764
  Gp5_im_re_a2 (0 x5_im_a2 x5_re_a2 0) vccs gm=-3.026109416e+10
  Rp5_im_im_a2 (0 x5_im_a2) defmod_r r=1e-09
  Cx6_re_a2 (x6_re_a2 0) defmod_c c=0.01004943133
  Gx6_re_a2 (0 x6_re_a2 p2 0) vccs gm=0.001421204207
  Fx6_re_a2 (0 x6_re_a2) cccs probe=V2 gain=0.07106021037
  Rp6_re_re_a2 (0 x6_re_a2) defmod_r r=1e-09
  Gp6_re_im_a2 (0 x6_re_a2 x6_im_a2 0) vccs gm=1.189747778e+10
  Cx6_im_a2 (x6_im_a2 0) defmod_c c=0.01004943133
  Gp6_im_re_a2 (0 x6_im_a2 x6_re_a2 0) vccs gm=-1.189747778e+10
  Rp6_im_im_a2 (0 x6_im_a2) defmod_r r=1e-09
  Cx7_re_a2 (x7_re_a2 0) defmod_c c=0.01056929241
  Gx7_re_a2 (0 x7_re_a2 p2 0) vccs gm=0.001494723668
  Fx7_re_a2 (0 x7_re_a2) cccs probe=V2 gain=0.07473618339
  Rp7_re_re_a2 (0 x7_re_a2) defmod_r r=1e-09
  Gp7_re_im_a2 (0 x7_re_a2 x7_im_a2 0) vccs gm=1.242993984e+10
  Cx7_im_a2 (x7_im_a2 0) defmod_c c=0.01056929241
  Gp7_im_re_a2 (0 x7_im_a2 x7_re_a2 0) vccs gm=-1.242993984e+10
  Rp7_im_im_a2 (0 x7_im_a2) defmod_r r=1e-09
ends
