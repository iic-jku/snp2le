* two_port - lumped-element equivalent (Xyce)
* generated by snp2le 0.2.2
* EQUIVALENT CIRCUIT FOR VECTOR FITTED S-MATRIX
* Created using scikit-rf vectorFitting.py
*
*
.SUBCKT two_port p1 p2
V1 p1 s1 0.0
GR1 s1 0 s1 0 0.02
Gd1_1 0 s1 p1 0 -0.01152203663908645
Fd1_1 0 s1 V1 -0.5761018319543225
Gr1_1_1 0 s1 x1_a1 0 1.8033127218047407
Gr2_re_1_1 0 s1 x2_re_a1 0 534719.9232150627
Gr2_im_1_1 0 s1 x2_im_a1 0 1512943.0297434316
Gr3_re_1_1 0 s1 x3_re_a1 0 203181.42968822052
Gr3_im_1_1 0 s1 x3_im_a1 0 -211072.95006604612
Gr4_re_1_1 0 s1 x4_re_a1 0 243746.90643030833
Gr4_im_1_1 0 s1 x4_im_a1 0 -348898.65536814375
Gr5_re_1_1 0 s1 x5_re_a1 0 104716.97920732485
Gr5_im_1_1 0 s1 x5_im_a1 0 -530625.8255647421
Gr6_re_1_1 0 s1 x6_re_a1 0 654099.5029507009
Gr6_im_1_1 0 s1 x6_im_a1 0 -467750.21940077364
Gr7_re_1_1 0 s1 x7_re_a1 0 473228.4146775495
Gr7_im_1_1 0 s1 x7_im_a1 0 36287.144471270265
Gd1_2 0 s1 p2 0 6.593143832938093e-05
Fd1_2 0 s1 V2 0.003296571916469047
Gr1_1_2 0 s1 x1_a2 0 -0.001461005041022524
Gr2_re_1_2 0 s1 x2_re_a2 0 -4740.598471982206
Gr2_im_1_2 0 s1 x2_im_a2 0 -4438.937648033163
Gr3_re_1_2 0 s1 x3_re_a2 0 -201757.9974604988
Gr3_im_1_2 0 s1 x3_im_a2 0 213436.2220160865
Gr4_re_1_2 0 s1 x4_re_a2 0 243571.0498354919
Gr4_im_1_2 0 s1 x4_im_a2 0 -351420.2071097562
Gr5_re_1_2 0 s1 x5_re_a2 0 -101885.84857924214
Gr5_im_1_2 0 s1 x5_im_a2 0 537570.5117343562
Gr6_re_1_2 0 s1 x6_re_a2 0 125643.6221658176
Gr6_im_1_2 0 s1 x6_im_a2 0 305090.94462860754
Gr7_re_1_2 0 s1 x7_re_a2 0 -155198.96822849713
Gr7_im_1_2 0 s1 x7_im_a2 0 -393590.82486262394
Cx1_a1 x1_a1 0 2.4717152447090583e-12
Gx1_a1 0 x1_a1 p1 0 0.03606625443609481
Fx1_a1 0 x1_a1 V1 1.8033127218047407
GRp1_a1 0 x1_a1 0 x1_a1 1.0
Cx2_re_a1 x2_re_a1 0 6.28342386029933e-13
Gx2_re_a1 0 x2_re_a1 p1 0 7.447230972211256e-08
Fx2_re_a1 0 x2_re_a1 V1 3.7236154861056283e-06
GRp2_re_re_a1 0 x2_re_a1 0 x2_re_a1 1.0
Gp2_re_im_a1 0 x2_re_a1 x2_im_a1 0 1.07322554582539
Cx2_im_a1 x2_im_a1 0 6.28342386029933e-13
Gp2_im_re_a1 0 x2_im_a1 x2_re_a1 0 -1.07322554582539
GRp2_im_im_a1 0 x2_im_a1 0 x2_im_a1 1.0
Cx3_re_a1 x3_re_a1 0 3.881034056320516e-11
Gx3_re_a1 0 x3_re_a1 p1 0 3.180534020067262e-08
Fx3_re_a1 0 x3_re_a1 V1 1.5902670100336312e-06
GRp3_re_re_a1 0 x3_re_a1 0 x3_re_a1 1.0
Gp3_re_im_a1 0 x3_re_a1 x3_im_a1 0 35.92719924914911
Cx3_im_a1 x3_im_a1 0 3.881034056320516e-11
Gp3_im_re_a1 0 x3_im_a1 x3_re_a1 0 -35.92719924914911
GRp3_im_im_a1 0 x3_im_a1 0 x3_im_a1 1.0
Cx4_re_a1 x4_re_a1 0 2.8164940143568674e-11
Gx4_re_a1 0 x4_re_a1 p1 0 4.181410740599837e-08
Fx4_re_a1 0 x4_re_a1 V1 2.0907053702999182e-06
GRp4_re_re_a1 0 x4_re_a1 0 x4_re_a1 1.0
Gp4_re_im_a1 0 x4_re_a1 x4_im_a1 0 27.885108044984953
Cx4_im_a1 x4_im_a1 0 2.8164940143568674e-11
Gp4_im_re_a1 0 x4_im_a1 x4_re_a1 0 -27.885108044984953
GRp4_im_im_a1 0 x4_im_a1 0 x4_im_a1 1.0
Cx5_re_a1 x5_re_a1 0 2.83223176399262e-11
Gx5_re_a1 0 x5_re_a1 p1 0 3.138861629888815e-08
Fx5_re_a1 0 x5_re_a1 V1 1.5694308149444076e-06
GRp5_re_re_a1 0 x5_re_a1 0 x5_re_a1 1.0
Gp5_re_im_a1 0 x5_re_a1 x5_im_a1 0 30.261094162388975
Cx5_im_a1 x5_im_a1 0 2.83223176399262e-11
Gp5_im_re_a1 0 x5_im_a1 x5_re_a1 0 -30.261094162388975
GRp5_im_im_a1 0 x5_im_a1 0 x5_im_a1 1.0
Cx6_re_a1 x6_re_a1 0 1.0049431325619422e-11
Gx6_re_a1 0 x6_re_a1 p1 0 6.607398364558817e-08
Fx6_re_a1 0 x6_re_a1 V1 3.3036991822794087e-06
GRp6_re_re_a1 0 x6_re_a1 0 x6_re_a1 1.0000000000000002
Gp6_re_im_a1 0 x6_re_a1 x6_im_a1 0 11.89747778451611
Cx6_im_a1 x6_im_a1 0 1.0049431325619422e-11
Gp6_im_re_a1 0 x6_im_a1 x6_re_a1 0 -11.89747778451611
GRp6_im_im_a1 0 x6_im_a1 0 x6_im_a1 1.0000000000000002
Cx7_re_a1 x7_re_a1 0 1.056929241493982e-11
Gx7_re_a1 0 x7_re_a1 p1 0 5.305124587160964e-08
Fx7_re_a1 0 x7_re_a1 V1 2.6525622935804824e-06
GRp7_re_re_a1 0 x7_re_a1 0 x7_re_a1 1.0
Gp7_re_im_a1 0 x7_re_a1 x7_im_a1 0 12.429939839800445
Cx7_im_a1 x7_im_a1 0 1.056929241493982e-11
Gp7_im_re_a1 0 x7_im_a1 x7_re_a1 0 -12.429939839800445
GRp7_im_im_a1 0 x7_im_a1 0 x7_im_a1 1.0
V2 p2 s2 0.0
GR2 s2 0 s2 0 0.02
Gd2_1 0 s2 p1 0 6.593948541713157e-05
Fd2_1 0 s2 V1 0.0032969742708565787
Gr1_2_1 0 s2 x1_a1 0 -0.0014609977788252724
Gr2_re_2_1 0 s2 x2_re_a1 0 -4734.387886112298
Gr2_im_2_1 0 s2 x2_im_a1 0 -4432.9113652319165
Gr3_re_2_1 0 s2 x3_re_a1 0 -201651.0840245045
Gr3_im_2_1 0 s2 x3_im_a1 0 213323.10710284556
Gr4_re_2_1 0 s2 x4_re_a1 0 243670.2356235858
Gr4_im_2_1 0 s2 x4_im_a1 0 -351563.3148414279
Gr5_re_2_1 0 s2 x5_re_a1 0 -101785.84094682
Gr5_im_2_1 0 s2 x5_im_a1 0 537042.8224640219
Gr6_re_2_1 0 s2 x6_re_a1 0 115164.43115008736
Gr6_im_2_1 0 s2 x6_im_a1 0 279644.8047664497
Gr7_re_2_1 0 s2 x7_re_a1 0 -162173.76724148457
Gr7_im_2_1 0 s2 x7_im_a1 0 -411279.05412805465
Gd2_2 0 s2 p2 0 -0.01149510093523139
Fd2_2 0 s2 V2 -0.5747550467615695
Gr1_2_2 0 s2 x1_a2 0 1.8033628202085088
Gr2_re_2_2 0 s2 x2_re_a2 0 533073.5114068299
Gr2_im_2_2 0 s2 x2_im_a2 0 1513487.6919168297
Gr3_re_2_2 0 s2 x3_re_a2 0 202858.59502031113
Gr3_im_2_2 0 s2 x3_im_a2 0 -212487.22056929162
Gr4_re_2_2 0 s2 x4_re_a2 0 243327.599961049
Gr4_im_2_2 0 s2 x4_im_a2 0 -352103.7005780822
Gr5_re_2_2 0 s2 x5_re_a2 0 103993.45312707715
Gr5_im_2_2 0 s2 x5_im_a2 0 -539718.1595766082
Gr6_re_2_2 0 s2 x6_re_a2 0 643625.5820062507
Gr6_im_2_2 0 s2 x6_im_a2 0 -399372.48718196445
Gr7_re_2_2 0 s2 x7_re_a2 0 539938.8576475873
Gr7_im_2_2 0 s2 x7_im_a2 0 -87082.7284811242
Cx1_a2 x1_a2 0 2.4717152447090583e-12
Gx1_a2 0 x1_a2 p2 0 0.03606725640417018
Fx1_a2 0 x1_a2 V2 1.803362820208509
GRp1_a2 0 x1_a2 0 x1_a2 1.0
Cx2_re_a2 x2_re_a2 0 6.28342386029933e-13
Gx2_re_a2 0 x2_re_a2 p2 0 7.437095379829712e-08
Fx2_re_a2 0 x2_re_a2 V2 3.718547689914856e-06
GRp2_re_re_a2 0 x2_re_a2 0 x2_re_a2 1.0
Gp2_re_im_a2 0 x2_re_a2 x2_im_a2 0 1.07322554582539
Cx2_im_a2 x2_im_a2 0 6.28342386029933e-13
Gp2_im_re_a2 0 x2_im_a2 x2_re_a2 0 -1.07322554582539
GRp2_im_im_a2 0 x2_im_a2 0 x2_im_a2 1.0
Cx3_re_a2 x3_re_a2 0 3.881034056320516e-11
Gx3_re_a2 0 x3_re_a2 p2 0 3.178848702454841e-08
Fx3_re_a2 0 x3_re_a2 V2 1.5894243512274206e-06
GRp3_re_re_a2 0 x3_re_a2 0 x3_re_a2 1.0
Gp3_re_im_a2 0 x3_re_a2 x3_im_a2 0 35.92719924914911
Cx3_im_a2 x3_im_a2 0 3.881034056320516e-11
Gp3_im_re_a2 0 x3_im_a2 x3_re_a2 0 -35.92719924914911
GRp3_im_im_a2 0 x3_im_a2 0 x3_im_a2 1.0
Cx4_re_a2 x4_re_a2 0 2.8164940143568674e-11
Gx4_re_a2 0 x4_re_a2 p2 0 4.183113299773076e-08
Fx4_re_a2 0 x4_re_a2 V2 2.091556649886538e-06
GRp4_re_re_a2 0 x4_re_a2 0 x4_re_a2 1.0
Gp4_re_im_a2 0 x4_re_a2 x4_im_a2 0 27.885108044984953
Cx4_im_a2 x4_im_a2 0 2.8164940143568674e-11
Gp4_im_re_a2 0 x4_im_a2 x4_re_a2 0 -27.885108044984953
GRp4_im_im_a2 0 x4_im_a2 0 x4_im_a2 1.0
Cx5_re_a2 x5_re_a2 0 2.83223176399262e-11
Gx5_re_a2 0 x5_re_a2 p2 0 3.1357806443654126e-08
Fx5_re_a2 0 x5_re_a2 V2 1.5678903221827062e-06
GRp5_re_re_a2 0 x5_re_a2 0 x5_re_a2 1.0
Gp5_re_im_a2 0 x5_re_a2 x5_im_a2 0 30.261094162388975
Cx5_im_a2 x5_im_a2 0 2.83223176399262e-11
Gp5_im_re_a2 0 x5_im_a2 x5_re_a2 0 -30.261094162388975
GRp5_im_im_a2 0 x5_im_a2 0 x5_im_a2 1.0
Cx6_re_a2 x6_re_a2 0 1.0049431325619422e-11
Gx6_re_a2 0 x6_re_a2 p2 0 6.056298917644497e-08
Fx6_re_a2 0 x6_re_a2 V2 3.0281494588222482e-06
GRp6_re_re_a2 0 x6_re_a2 0 x6_re_a2 1.0000000000000002
Gp6_re_im_a2 0 x6_re_a2 x6_im_a2 0 11.89747778451611
Cx6_im_a2 x6_im_a2 0 1.0049431325619422e-11
Gp6_im_re_a2 0 x6_im_a2 x6_re_a2 0 -11.89747778451611
GRp6_im_im_a2 0 x6_im_a2 0 x6_im_a2 1.0000000000000002
Cx7_re_a2 x7_re_a2 0 1.056929241493982e-11
Gx7_re_a2 0 x7_re_a2 p2 0 5.543533281460614e-08
Fx7_re_a2 0 x7_re_a2 V2 2.771766640730307e-06
GRp7_re_re_a2 0 x7_re_a2 0 x7_re_a2 1.0
Gp7_re_im_a2 0 x7_re_a2 x7_im_a2 0 12.429939839800445
Cx7_im_a2 x7_im_a2 0 1.056929241493982e-11
Gp7_im_re_a2 0 x7_im_a2 x7_re_a2 0 -12.429939839800445
GRp7_im_im_a2 0 x7_im_a2 0 x7_im_a2 1.0
.ENDS two_port
