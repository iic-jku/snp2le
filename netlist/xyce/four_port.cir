* four_port - lumped-element equivalent (Xyce)
* generated by snp2le 0.2.2
* EQUIVALENT CIRCUIT FOR VECTOR FITTED S-MATRIX
* Created using scikit-rf vectorFitting.py
*
*
.SUBCKT four_port p1 p2 p3 p4
V1 p1 s1 0.0
GR1 s1 0 s1 0 0.02
Gd1_1 0 s1 p1 0 0.0027163635006654534
Fd1_1 0 s1 V1 0.13581817503327268
Gr1_1_1 0 s1 x1_a1 0 -1.2420415258911779
Gr2_re_1_1 0 s1 x2_re_a1 0 443688.23741934355
Gr2_im_1_1 0 s1 x2_im_a1 0 118961.56939308195
Gr3_1_1 0 s1 x3_a1 0 0.7798650764894156
Gr4_re_1_1 0 s1 x4_re_a1 0 631432.608705504
Gr4_im_1_1 0 s1 x4_im_a1 0 -116161.32382502848
Gr5_re_1_1 0 s1 x5_re_a1 0 696027.1896799202
Gr5_im_1_1 0 s1 x5_im_a1 0 -62024.54776048056
Gd1_2 0 s1 p2 0 0.0011985463894318732
Fd1_2 0 s1 V2 0.05992731947159367
Gr1_1_2 0 s1 x1_a2 0 -0.03766812696658492
Gr2_re_1_2 0 s1 x2_re_a2 0 -567181.2015947185
Gr2_im_1_2 0 s1 x2_im_a2 0 238875.53014523847
Gr3_1_2 0 s1 x3_a2 0 0.7926751572726645
Gr4_re_1_2 0 s1 x4_re_a2 0 -641933.0273463265
Gr4_im_1_2 0 s1 x4_im_a2 0 113076.82113050723
Gr5_re_1_2 0 s1 x5_re_a2 0 692430.8664850285
Gr5_im_1_2 0 s1 x5_im_a2 0 -66626.40525404343
Gd1_3 0 s1 p3 0 -0.0004137960440778071
Fd1_3 0 s1 V3 -0.020689802203890356
Gr1_1_3 0 s1 x1_a3 0 -0.05819064407393421
Gr2_re_1_3 0 s1 x2_re_a3 0 555703.9691902848
Gr2_im_1_3 0 s1 x2_im_a3 0 -393259.90560985607
Gr3_1_3 0 s1 x3_a3 0 0.8126755223310257
Gr4_re_1_3 0 s1 x4_re_a3 0 -638421.8077180006
Gr4_im_1_3 0 s1 x4_im_a3 0 116247.33142171062
Gr5_re_1_3 0 s1 x5_re_a3 0 -698613.6706859168
Gr5_im_1_3 0 s1 x5_im_a3 0 63618.7562286719
Gd1_4 0 s1 p4 0 0.0007908438152432353
Fd1_4 0 s1 V4 0.03954219076216176
Gr1_1_4 0 s1 x1_a4 0 -0.0255230399435401
Gr2_re_1_4 0 s1 x2_re_a4 0 -587756.7944235938
Gr2_im_1_4 0 s1 x2_im_a4 0 272010.1647833048
Gr3_1_4 0 s1 x3_a4 0 0.7981630451125362
Gr4_re_1_4 0 s1 x4_re_a4 0 643410.3673016345
Gr4_im_1_4 0 s1 x4_im_a4 0 -120363.96372231787
Gr5_re_1_4 0 s1 x5_re_a4 0 -693802.24052517
Gr5_im_1_4 0 s1 x5_im_a4 0 63189.09075449131
Cx1_a1 x1_a1 0 3.190629032257628e-13
Gx1_a1 0 x1_a1 p1 0 0.024840830517823553
Fx1_a1 0 x1_a1 V1 1.2420415258911777
GRp1_a1 0 x1_a1 0 x1_a1 1.0
Cx2_re_a1 x2_re_a1 0 1.859227378349775e-12
Gx2_re_a1 0 x2_re_a1 p1 0 3.309545825299302e-08
Fx2_re_a1 0 x2_re_a1 V1 1.654772912649651e-06
GRp2_re_re_a1 0 x2_re_a1 0 x2_re_a1 1.0
Gp2_re_im_a1 0 x2_re_a1 x2_im_a1 0 3.81959767127151
Cx2_im_a1 x2_im_a1 0 1.859227378349775e-12
Gp2_im_re_a1 0 x2_im_a1 x2_re_a1 0 -3.81959767127151
GRp2_im_im_a1 0 x2_im_a1 0 x2_im_a1 1.0
Cx3_a1 x3_a1 0 1.544151282207838e-12
Gx3_a1 0 x3_a1 p1 0 0.01625351044663172
Fx3_a1 0 x3_a1 V1 0.812675522331586
GRp3_a1 0 x3_a1 0 x3_a1 1.0
Cx4_re_a1 x4_re_a1 0 2.8158481127115875e-12
Gx4_re_a1 0 x4_re_a1 p1 0 3.433629192873397e-08
Fx4_re_a1 0 x4_re_a1 V1 1.7168145964366987e-06
GRp4_re_re_a1 0 x4_re_a1 0 x4_re_a1 1.0
Gp4_re_im_a1 0 x4_re_a1 x4_im_a1 0 3.2274765694752885
Cx4_im_a1 x4_im_a1 0 2.8158481127115875e-12
Gp4_im_re_a1 0 x4_im_a1 x4_re_a1 0 -3.2274765694752885
GRp4_im_im_a1 0 x4_im_a1 0 x4_im_a1 1.0
Cx5_re_a1 x5_re_a1 0 3.0402983169291383e-12
Gx5_re_a1 0 x5_re_a1 p1 0 3.172222253859869e-08
Fx5_re_a1 0 x5_re_a1 V1 1.5861111269299342e-06
GRp5_re_re_a1 0 x5_re_a1 0 x5_re_a1 1.0
Gp5_re_im_a1 0 x5_re_a1 x5_im_a1 0 2.9246040446706565
Cx5_im_a1 x5_im_a1 0 3.0402983169291383e-12
Gp5_im_re_a1 0 x5_im_a1 x5_re_a1 0 -2.9246040446706565
GRp5_im_im_a1 0 x5_im_a1 0 x5_im_a1 1.0
V2 p2 s2 0.0
GR2 s2 0 s2 0 0.02
Gd2_1 0 s2 p1 0 0.001198546389429187
Fd2_1 0 s2 V1 0.05992731947145935
Gr1_2_1 0 s2 x1_a1 0 -0.03760927994807973
Gr2_re_2_1 0 s2 x2_re_a1 0 -567180.8110358289
Gr2_im_2_1 0 s2 x2_im_a1 0 238875.36565661783
Gr3_2_1 0 s2 x3_a1 0 0.7926643340263211
Gr4_re_2_1 0 s2 x4_re_a1 0 -641042.0963323076
Gr4_im_2_1 0 s2 x4_im_a1 0 112919.88319047567
Gr5_re_2_1 0 s2 x5_re_a1 0 692524.9578497575
Gr5_im_2_1 0 s2 x5_im_a1 0 -66635.45882120088
Gd2_2 0 s2 p2 0 0.0026598572004266708
Fd2_2 0 s2 V2 0.13299286002133354
Gr1_2_2 0 s2 x1_a2 0 -1.2401011469498897
Gr2_re_2_2 0 s2 x2_re_a2 0 442596.5226398844
Gr2_im_2_2 0 s2 x2_im_a2 0 120287.70205945779
Gr3_2_2 0 s2 x3_a2 0 0.7791214314302977
Gr4_re_2_2 0 s2 x4_re_a2 0 630987.3888459941
Gr4_im_2_2 0 s2 x4_im_a2 0 -115831.98265957476
Gr5_re_2_2 0 s2 x5_re_a2 0 696547.8885913936
Gr5_im_2_2 0 s2 x5_im_a2 0 -61210.09503685238
Gd2_3 0 s2 p3 0 0.0007940807327400815
Fd2_3 0 s2 V3 0.03970403663700408
Gr1_2_3 0 s2 x1_a3 0 -0.025561777329182484
Gr2_re_2_3 0 s2 x2_re_a3 0 -587826.1247729146
Gr2_im_2_3 0 s2 x2_im_a3 0 270453.99558329146
Gr3_2_3 0 s2 x3_a3 0 0.7973291100473986
Gr4_re_2_3 0 s2 x4_re_a3 0 643490.4123871406
Gr4_im_2_3 0 s2 x4_im_a3 0 -120015.16143011281
Gr5_re_2_3 0 s2 x5_re_a3 0 -694157.9450915697
Gr5_im_2_3 0 s2 x5_im_a3 0 62516.73111633947
Gd2_4 0 s2 p4 0 -0.00041353263530290564
Fd2_4 0 s2 V4 -0.020676631765145285
Gr1_2_4 0 s2 x1_a4 0 -0.058101625978147664
Gr2_re_2_4 0 s2 x2_re_a4 0 555644.6319632708
Gr2_im_2_4 0 s2 x2_im_a4 0 -393212.44001157867
Gr3_2_4 0 s2 x3_a4 0 0.8126644259911281
Gr4_re_2_4 0 s2 x4_re_a4 0 -637052.9397912663
Gr4_im_2_4 0 s2 x4_im_a4 0 116089.1674165527
Gr5_re_2_4 0 s2 x5_re_a4 0 -698898.5039444617
Gr5_im_2_4 0 s2 x5_im_a4 0 63507.99217764795
Cx1_a2 x1_a2 0 3.190629032257628e-13
Gx1_a2 0 x1_a2 p2 0 0.024802022938997793
Fx1_a2 0 x1_a2 V2 1.2401011469498897
GRp1_a2 0 x1_a2 0 x1_a2 1.0
Cx2_re_a2 x2_re_a2 0 1.859227378349775e-12
Gx2_re_a2 0 x2_re_a2 p2 0 3.3095435463582134e-08
Fx2_re_a2 0 x2_re_a2 V2 1.6547717731791068e-06
GRp2_re_re_a2 0 x2_re_a2 0 x2_re_a2 1.0
Gp2_re_im_a2 0 x2_re_a2 x2_im_a2 0 3.81959767127151
Cx2_im_a2 x2_im_a2 0 1.859227378349775e-12
Gp2_im_re_a2 0 x2_im_a2 x2_re_a2 0 -3.81959767127151
GRp2_im_im_a2 0 x2_im_a2 0 x2_im_a2 1.0
Cx3_a2 x3_a2 0 1.544151282207838e-12
Gx3_a2 0 x3_a2 p2 0 0.016253288519977923
Fx3_a2 0 x3_a2 V2 0.8126644259988962
GRp3_a2 0 x3_a2 0 x3_a2 1.0
Cx4_re_a2 x4_re_a2 0 2.8158481127115875e-12
Gx4_re_a2 0 x4_re_a2 p2 0 3.428863700823051e-08
Fx4_re_a2 0 x4_re_a2 V2 1.7144318504115256e-06
GRp4_re_re_a2 0 x4_re_a2 0 x4_re_a2 1.0
Gp4_re_im_a2 0 x4_re_a2 x4_im_a2 0 3.2274765694752885
Cx4_im_a2 x4_im_a2 0 2.8158481127115875e-12
Gp4_im_re_a2 0 x4_im_a2 x4_re_a2 0 -3.2274765694752885
GRp4_im_im_a2 0 x4_im_a2 0 x4_im_a2 1.0
Cx5_re_a2 x5_re_a2 0 3.0402983169291383e-12
Gx5_re_a2 0 x5_re_a2 p2 0 3.172653313097252e-08
Fx5_re_a2 0 x5_re_a2 V2 1.586326656548626e-06
GRp5_re_re_a2 0 x5_re_a2 0 x5_re_a2 1.0
Gp5_re_im_a2 0 x5_re_a2 x5_im_a2 0 2.9246040446706565
Cx5_im_a2 x5_im_a2 0 3.0402983169291383e-12
Gp5_im_re_a2 0 x5_im_a2 x5_re_a2 0 -2.9246040446706565
GRp5_im_im_a2 0 x5_im_a2 0 x5_im_a2 1.0
V3 p3 s3 0.0
GR3 s3 0 s3 0 0.02
Gd3_1 0 s3 p1 0 -0.000413796044035686
Fd3_1 0 s3 V1 -0.020689802201784298
Gr1_3_1 0 s3 x1_a1 0 -0.05808956409424728
Gr2_re_3_1 0 s3 x2_re_a1 0 555736.9343068426
Gr2_im_3_1 0 s3 x2_im_a1 0 -393283.23432632774
Gr3_3_1 0 s3 x3_a1 0 0.8126755223315862
Gr4_re_3_1 0 s3 x4_re_a1 0 -637535.7498810758
Gr4_im_3_1 0 s3 x4_im_a1 0 116085.99316847695
Gr5_re_3_1 0 s3 x5_re_a1 0 -698704.5658440302
Gr5_im_3_1 0 s3 x5_im_a1 0 63627.033531038964
Gd3_2 0 s3 p2 0 0.0007940807328549141
Fd3_2 0 s3 V2 0.03970403664274571
Gr1_3_2 0 s3 x1_a2 0 -0.025557302171951887
Gr2_re_3_2 0 s3 x2_re_a2 0 -587861.4002200216
Gr2_im_3_2 0 s3 x2_im_a2 0 270470.22551996715
Gr3_3_2 0 s3 x3_a2 0 0.7973399969896299
Gr4_re_3_2 0 s3 x4_re_a2 0 643490.4123861762
Gr4_im_3_2 0 s3 x4_im_a2 0 -120015.16143078251
Gr5_re_3_2 0 s3 x5_re_a2 0 -694153.9350197933
Gr5_im_3_2 0 s3 x5_im_a2 0 62516.36996378596
Gd3_3 0 s3 p3 0 0.002653062700638854
Fd3_3 0 s3 V3 0.1326531350319427
Gr1_3_3 0 s3 x1_a3 0 -1.2398840392552941
Gr2_re_3_3 0 s3 x2_re_a3 0 442514.33677075413
Gr2_im_3_3 0 s3 x2_im_a3 0 120329.63237595286
Gr3_3_3 0 s3 x3_a3 0 0.7789670267491514
Gr4_re_3_3 0 s3 x4_re_a3 0 631420.704363828
Gr4_im_3_3 0 s3 x4_im_a3 0 -115671.41432518332
Gr5_re_3_3 0 s3 x5_re_a3 0 695880.4191726645
Gr5_im_3_3 0 s3 x5_im_a3 0 -61358.34893211291
Gd3_4 0 s3 p4 0 0.0011973961894663487
Fd3_4 0 s3 V4 0.059869809473317444
Gr1_3_4 0 s3 x1_a4 0 -0.037533826651946656
Gr2_re_3_4 0 s3 x2_re_a4 0 -567067.7548362153
Gr2_im_3_4 0 s3 x2_im_a4 0 238751.0335142873
Gr3_3_4 0 s3 x3_a4 0 0.7924598497629476
Gr4_re_3_4 0 s3 x4_re_a4 0 -640993.7710788108
Gr4_im_3_4 0 s3 x4_im_a4 0 112763.78304102196
Gr5_re_3_4 0 s3 x5_re_a4 0 692070.5770978219
Gr5_im_3_4 0 s3 x5_im_a4 0 -66652.41450181583
Cx1_a3 x1_a3 0 3.190629032257628e-13
Gx1_a3 0 x1_a3 p3 0 0.02479768078510588
Fx1_a3 0 x1_a3 V3 1.2398840392552941
GRp1_a3 0 x1_a3 0 x1_a3 1.0
Cx2_re_a3 x2_re_a3 0 1.859227378349775e-12
Gx2_re_a3 0 x2_re_a3 p3 0 3.309742152065288e-08
Fx2_re_a3 0 x2_re_a3 V3 1.6548710760326442e-06
GRp2_re_re_a3 0 x2_re_a3 0 x2_re_a3 1.0
Gp2_re_im_a3 0 x2_re_a3 x2_im_a3 0 3.81959767127151
Cx2_im_a3 x2_im_a3 0 1.859227378349775e-12
Gp2_im_re_a3 0 x2_im_a3 x2_re_a3 0 -3.81959767127151
GRp2_im_im_a3 0 x2_im_a3 0 x2_im_a3 1.0
Cx3_a3 x3_a3 0 1.544151282207838e-12
Gx3_a3 0 x3_a3 p3 0 0.01625351044662051
Fx3_a3 0 x3_a3 V3 0.8126755223310256
GRp3_a3 0 x3_a3 0 x3_a3 1.0
Cx4_re_a3 x4_re_a3 0 2.8158481127115875e-12
Gx4_re_a3 0 x4_re_a3 p3 0 3.4288637008160544e-08
Fx4_re_a3 0 x4_re_a3 V3 1.7144318504080274e-06
GRp4_re_re_a3 0 x4_re_a3 0 x4_re_a3 1.0
Gp4_re_im_a3 0 x4_re_a3 x4_im_a3 0 3.2274765694752885
Cx4_im_a3 x4_im_a3 0 2.8158481127115875e-12
Gp4_im_re_a3 0 x4_im_a3 x4_re_a3 0 -3.2274765694752885
GRp4_im_im_a3 0 x4_im_a3 0 x4_im_a3 1.0
Cx5_re_a3 x5_re_a3 0 3.0402983169291383e-12
Gx5_re_a3 0 x5_re_a3 p3 0 3.172634985036492e-08
Fx5_re_a3 0 x5_re_a3 V3 1.586317492518246e-06
GRp5_re_re_a3 0 x5_re_a3 0 x5_re_a3 1.0
Gp5_re_im_a3 0 x5_re_a3 x5_im_a3 0 2.9246040446706565
Cx5_im_a3 x5_im_a3 0 3.0402983169291383e-12
Gp5_im_re_a3 0 x5_im_a3 x5_re_a3 0 -2.9246040446706565
GRp5_im_im_a3 0 x5_im_a3 0 x5_im_a3 1.0
V4 p4 s4 0.0
GR4 s4 0 s4 0 0.02
Gd4_1 0 s4 p1 0 0.0007908438152113841
Fd4_1 0 s4 V1 0.03954219076056921
Gr1_4_1 0 s4 x1_a1 0 -0.02551800592568076
Gr2_re_4_1 0 s4 x2_re_a1 0 -587721.5252392428
Gr2_im_4_1 0 s4 x2_im_a1 0 271993.8424277419
Gr3_4_1 0 s4 x3_a1 0 0.7981521469258254
Gr4_re_4_1 0 s4 x4_re_a1 0 643410.3673017493
Gr4_im_4_1 0 s4 x4_im_a1 0 -120363.96372218948
Gr5_re_4_1 0 s4 x5_re_a1 0 -693986.7996543691
Gr5_im_4_1 0 s4 x5_im_a1 0 63205.89975716114
Gd4_2 0 s4 p2 0 -0.00041353263475122444
Fd4_2 0 s4 V2 -0.02067663173756122
Gr1_4_2 0 s4 x1_a2 0 -0.05818105973951533
Gr2_re_4_2 0 s4 x2_re_a2 0 555611.6723064714
Gr2_im_4_2 0 s4 x2_im_a2 0 -393189.1155248072
Gr3_4_2 0 s4 x3_a2 0 0.8126644259988962
Gr4_re_4_2 0 s4 x4_re_a2 0 -637938.3266050006
Gr4_im_4_2 0 s4 x4_im_a2 0 116250.51007574254
Gr5_re_4_2 0 s4 x5_re_a2 0 -698989.4361595727
Gr5_im_4_2 0 s4 x5_im_a2 0 63516.2550648574
Gd4_3 0 s4 p3 0 0.0011973961897488112
Fd4_3 0 s4 V3 0.05986980948744056
Gr1_4_3 0 s4 x1_a3 0 -0.03759172237376574
Gr2_re_4_3 0 s4 x2_re_a3 0 -567000.091914001
Gr2_im_4_3 0 s4 x2_im_a3 0 238722.5455543614
Gr3_4_3 0 s4 x3_a3 0 0.7924490294567216
Gr4_re_4_3 0 s4 x4_re_a3 0 -641884.6349303493
Gr4_im_4_3 0 s4 x4_im_a3 0 112920.5040294397
Gr5_re_4_3 0 s4 x5_re_a3 0 692164.6194997497
Gr5_im_4_3 0 s4 x5_im_a3 0 -66661.47160429812
Gd4_4 0 s4 p4 0 0.0027114664360496843
Fd4_4 0 s4 V4 0.13557332180248421
Gr1_4_4 0 s4 x1_a4 0 -1.2417965528744612
Gr2_re_4_4 0 s4 x2_re_a4 0 443174.4105964312
Gr2_im_4_4 0 s4 x2_im_a4 0 118893.82815463304
Gr3_4_4 0 s4 x3_a4 0 0.7796718859903066
Gr4_re_4_4 0 s4 x4_re_a4 0 630896.0809818491
Gr4_im_4_4 0 s4 x4_im_a4 0 -116012.40585158789
Gr5_re_4_4 0 s4 x5_re_a4 0 695926.4901657415
Gr5_im_4_4 0 s4 x5_im_a4 0 -61949.45099359619
Cx1_a4 x1_a4 0 3.190629032257628e-13
Gx1_a4 0 x1_a4 p4 0 0.024835931057489224
Fx1_a4 0 x1_a4 V4 1.2417965528744612
GRp1_a4 0 x1_a4 0 x1_a4 1.0
Cx2_re_a4 x2_re_a4 0 1.859227378349775e-12
Gx2_re_a4 0 x2_re_a4 p4 0 3.309347231285587e-08
Fx2_re_a4 0 x2_re_a4 V4 1.6546736156427937e-06
GRp2_re_re_a4 0 x2_re_a4 0 x2_re_a4 1.0
Gp2_re_im_a4 0 x2_re_a4 x2_im_a4 0 3.81959767127151
Cx2_im_a4 x2_im_a4 0 1.859227378349775e-12
Gp2_im_re_a4 0 x2_im_a4 x2_re_a4 0 -3.81959767127151
GRp2_im_im_a4 0 x2_im_a4 0 x2_im_a4 1.0
Cx3_a4 x3_a4 0 1.544151282207838e-12
Gx3_a4 0 x3_a4 p4 0 0.01625328851982256
Fx3_a4 0 x3_a4 V4 0.8126644259911282
GRp3_a4 0 x3_a4 0 x3_a4 1.0
Cx4_re_a4 x4_re_a4 0 2.8158481127115875e-12
Gx4_re_a4 0 x4_re_a4 p4 0 3.433629192874922e-08
Fx4_re_a4 0 x4_re_a4 V4 1.7168145964374612e-06
GRp4_re_re_a4 0 x4_re_a4 0 x4_re_a4 1.0
Gp4_re_im_a4 0 x4_re_a4 x4_im_a4 0 3.2274765694752885
Cx4_im_a4 x4_im_a4 0 2.8158481127115875e-12
Gp4_im_re_a4 0 x4_im_a4 x4_re_a4 0 -3.2274765694752885
GRp4_im_im_a4 0 x4_im_a4 0 x4_im_a4 1.0
Cx5_re_a4 x5_re_a4 0 3.0402983169291383e-12
Gx5_re_a4 0 x5_re_a4 p4 0 3.173066100337932e-08
Fx5_re_a4 0 x5_re_a4 V4 1.5865330501689661e-06
GRp5_re_re_a4 0 x5_re_a4 0 x5_re_a4 1.0
Gp5_re_im_a4 0 x5_re_a4 x5_im_a4 0 2.9246040446706565
Cx5_im_a4 x5_im_a4 0 3.0402983169291383e-12
Gp5_im_re_a4 0 x5_im_a4 x5_re_a4 0 -2.9246040446706565
GRp5_im_im_a4 0 x5_im_a4 0 x5_im_a4 1.0
.ENDS four_port
