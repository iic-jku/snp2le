* seven_port - lumped-element equivalent (ngspice / SPICE3)
* generated by snp2le
* EQUIVALENT CIRCUIT FOR VECTOR FITTED S-MATRIX
* Created using scikit-rf vectorFitting.py
*
*
.SUBCKT seven_port p1 p2 p3 p4 p5 p6 p7
V1 p1 s1 0
R1 s1 0 50
Gd1_1 0 s1 p1 0 -0.003058270328
Fd1_1 0 s1 V1 -0.1529135164
Gr1_1_1 0 s1 x1_a1 0 1.994550431e+11
Gr2_re_1_1 0 s1 x2_re_a1 0 -1.393230749e+11
Gr2_im_1_1 0 s1 x2_im_a1 0 4.705975776e+10
Gr3_re_1_1 0 s1 x3_re_a1 0 -5.100832055e+10
Gr3_im_1_1 0 s1 x3_im_a1 0 -3.477565324e+10
Gr4_re_1_1 0 s1 x4_re_a1 0 -920440073.3
Gr4_im_1_1 0 s1 x4_im_a1 0 708572940.9
Gr5_re_1_1 0 s1 x5_re_a1 0 4.782748401e+10
Gr5_im_1_1 0 s1 x5_im_a1 0 1.156858637e+10
Gr6_re_1_1 0 s1 x6_re_a1 0 -1.38450083e+10
Gr6_im_1_1 0 s1 x6_im_a1 0 5.78639625e+10
Gr7_re_1_1 0 s1 x7_re_a1 0 3286252211
Gr7_im_1_1 0 s1 x7_im_a1 0 -9970978909
Gr8_re_1_1 0 s1 x8_re_a1 0 5888980444
Gr8_im_1_1 0 s1 x8_im_a1 0 -7264318826
Gr9_re_1_1 0 s1 x9_re_a1 0 2889956231
Gr9_im_1_1 0 s1 x9_im_a1 0 -2556690202
Gr10_re_1_1 0 s1 x10_re_a1 0 7772960091
Gr10_im_1_1 0 s1 x10_im_a1 0 -5542774463
Gd1_2 0 s1 p2 0 1.900824155e-05
Fd1_2 0 s1 V2 0.0009504120777
Gr1_1_2 0 s1 x1_a2 0 1074839034
Gr2_re_1_2 0 s1 x2_re_a2 0 -326536695.5
Gr2_im_1_2 0 s1 x2_im_a2 0 -580873252.1
Gr3_re_1_2 0 s1 x3_re_a2 0 -270049938.4
Gr3_im_1_2 0 s1 x3_im_a2 0 959846854.6
Gr4_re_1_2 0 s1 x4_re_a2 0 -83437987.9
Gr4_im_1_2 0 s1 x4_im_a2 0 -1985257.873
Gr5_re_1_2 0 s1 x5_re_a2 0 -603257298.9
Gr5_im_1_2 0 s1 x5_im_a2 0 176620506.7
Gr6_re_1_2 0 s1 x6_re_a2 0 298493313
Gr6_im_1_2 0 s1 x6_im_a2 0 -1288218668
Gr7_re_1_2 0 s1 x7_re_a2 0 608357646.5
Gr7_im_1_2 0 s1 x7_im_a2 0 621600047
Gr8_re_1_2 0 s1 x8_re_a2 0 -13535224.07
Gr8_im_1_2 0 s1 x8_im_a2 0 617688457.3
Gr9_re_1_2 0 s1 x9_re_a2 0 -271400550.2
Gr9_im_1_2 0 s1 x9_im_a2 0 598411793.3
Gr10_re_1_2 0 s1 x10_re_a2 0 -237544578.2
Gr10_im_1_2 0 s1 x10_im_a2 0 -538837417.9
Gd1_3 0 s1 p3 0 -0.000233280334
Fd1_3 0 s1 V3 -0.0116640167
Gr1_1_3 0 s1 x1_a3 0 43870247.99
Gr2_re_1_3 0 s1 x2_re_a3 0 -3268310228
Gr2_im_1_3 0 s1 x2_im_a3 0 5305231646
Gr3_re_1_3 0 s1 x3_re_a3 0 3851176442
Gr3_im_1_3 0 s1 x3_im_a3 0 -2119736623
Gr4_re_1_3 0 s1 x4_re_a3 0 6854712.765
Gr4_im_1_3 0 s1 x4_im_a3 0 39940758.82
Gr5_re_1_3 0 s1 x5_re_a3 0 -883594795.9
Gr5_im_1_3 0 s1 x5_im_a3 0 -2315631646
Gr6_re_1_3 0 s1 x6_re_a3 0 1.130218465e+10
Gr6_im_1_3 0 s1 x6_im_a3 0 1.066906102e+10
Gr7_re_1_3 0 s1 x7_re_a3 0 -2309672730
Gr7_im_1_3 0 s1 x7_im_a3 0 -3221858727
Gr8_re_1_3 0 s1 x8_re_a3 0 -3044053731
Gr8_im_1_3 0 s1 x8_im_a3 0 -2302185939
Gr9_re_1_3 0 s1 x9_re_a3 0 246491235.3
Gr9_im_1_3 0 s1 x9_im_a3 0 -1782859184
Gr10_re_1_3 0 s1 x10_re_a3 0 543493771.5
Gr10_im_1_3 0 s1 x10_im_a3 0 2212433741
Gd1_4 0 s1 p4 0 5.026459991e-05
Fd1_4 0 s1 V4 0.002513229995
Gr1_1_4 0 s1 x1_a4 0 -7574783094
Gr2_re_1_4 0 s1 x2_re_a4 0 4390108420
Gr2_im_1_4 0 s1 x2_im_a4 0 801614958.8
Gr3_re_1_4 0 s1 x3_re_a4 0 -7428957218
Gr3_im_1_4 0 s1 x3_im_a4 0 -8045828079
Gr4_re_1_4 0 s1 x4_re_a4 0 -120484477.9
Gr4_im_1_4 0 s1 x4_im_a4 0 -12627712.38
Gr5_re_1_4 0 s1 x5_re_a4 0 -3663575277
Gr5_im_1_4 0 s1 x5_im_a4 0 1031670450
Gr6_re_1_4 0 s1 x6_re_a4 0 1.387560307e+10
Gr6_im_1_4 0 s1 x6_im_a4 0 -1.325491018e+10
Gr7_re_1_4 0 s1 x7_re_a4 0 -4599842354
Gr7_im_1_4 0 s1 x7_im_a4 0 2670766441
Gr8_re_1_4 0 s1 x8_re_a4 0 -2999865371
Gr8_im_1_4 0 s1 x8_im_a4 0 3855892052
Gr9_re_1_4 0 s1 x9_re_a4 0 -2119281639
Gr9_im_1_4 0 s1 x9_im_a4 0 -774463367.2
Gr10_re_1_4 0 s1 x10_re_a4 0 2993127970
Gr10_im_1_4 0 s1 x10_im_a4 0 -299915233.2
Gd1_5 0 s1 p5 0 -0.0002954509178
Fd1_5 0 s1 V5 -0.01477254589
Gr1_1_5 0 s1 x1_a5 0 928858082.4
Gr2_re_1_5 0 s1 x2_re_a5 0 -4937586570
Gr2_im_1_5 0 s1 x2_im_a5 0 6875797187
Gr3_re_1_5 0 s1 x3_re_a5 0 7013546249
Gr3_im_1_5 0 s1 x3_im_a5 0 -651315049.7
Gr4_re_1_5 0 s1 x4_re_a5 0 11457305.54
Gr4_im_1_5 0 s1 x4_im_a5 0 51531723.65
Gr5_re_1_5 0 s1 x5_re_a5 0 -1238196252
Gr5_im_1_5 0 s1 x5_im_a5 0 -2411543836
Gr6_re_1_5 0 s1 x6_re_a5 0 1.179152332e+10
Gr6_im_1_5 0 s1 x6_im_a5 0 1.226625664e+10
Gr7_re_1_5 0 s1 x7_re_a5 0 -1976721795
Gr7_im_1_5 0 s1 x7_im_a5 0 -3341431027
Gr8_re_1_5 0 s1 x8_re_a5 0 -3325149554
Gr8_im_1_5 0 s1 x8_im_a5 0 -2200381560
Gr9_re_1_5 0 s1 x9_re_a5 0 218788505.5
Gr9_im_1_5 0 s1 x9_im_a5 0 -1851072263
Gr10_re_1_5 0 s1 x10_re_a5 0 744123056
Gr10_im_1_5 0 s1 x10_im_a5 0 2399899446
Gd1_6 0 s1 p6 0 -3.798195841e-06
Fd1_6 0 s1 V6 -0.0001899097921
Gr1_1_6 0 s1 x1_a6 0 -9976179832
Gr2_re_1_6 0 s1 x2_re_a6 0 5369840234
Gr2_im_1_6 0 s1 x2_im_a6 0 923525381.1
Gr3_re_1_6 0 s1 x3_re_a6 0 -6183381499
Gr3_im_1_6 0 s1 x3_im_a6 0 -9411974154
Gr4_re_1_6 0 s1 x4_re_a6 0 -130336083.5
Gr4_im_1_6 0 s1 x4_im_a6 0 -38616840.61
Gr5_re_1_6 0 s1 x5_re_a6 0 -3568109753
Gr5_im_1_6 0 s1 x5_im_a6 0 1382413730
Gr6_re_1_6 0 s1 x6_re_a6 0 1.312295242e+10
Gr6_im_1_6 0 s1 x6_im_a6 0 -1.44198e+10
Gr7_re_1_6 0 s1 x7_re_a6 0 -4727272914
Gr7_im_1_6 0 s1 x7_im_a6 0 3238759296
Gr8_re_1_6 0 s1 x8_re_a6 0 -2674147096
Gr8_im_1_6 0 s1 x8_im_a6 0 4138363192
Gr9_re_1_6 0 s1 x9_re_a6 0 -2203738359
Gr9_im_1_6 0 s1 x9_im_a6 0 -680519080.5
Gr10_re_1_6 0 s1 x10_re_a6 0 3144048412
Gr10_im_1_6 0 s1 x10_im_a6 0 -533136713.9
Gd1_7 0 s1 p7 0 -2.211196201e-05
Fd1_7 0 s1 V7 -0.001105598101
Gr1_1_7 0 s1 x1_a7 0 1083935503
Gr2_re_1_7 0 s1 x2_re_a7 0 -414433722.8
Gr2_im_1_7 0 s1 x2_im_a7 0 -27640814.48
Gr3_re_1_7 0 s1 x3_re_a7 0 636091844.1
Gr3_im_1_7 0 s1 x3_im_a7 0 1127137204
Gr4_re_1_7 0 s1 x4_re_a7 0 -80428061.18
Gr4_im_1_7 0 s1 x4_im_a7 0 -11958434.29
Gr5_re_1_7 0 s1 x5_re_a7 0 -724748385.6
Gr5_im_1_7 0 s1 x5_im_a7 0 233123833.6
Gr6_re_1_7 0 s1 x6_re_a7 0 524847405.2
Gr6_im_1_7 0 s1 x6_im_a7 0 -959056394.6
Gr7_re_1_7 0 s1 x7_re_a7 0 557294093.6
Gr7_im_1_7 0 s1 x7_im_a7 0 618458291.1
Gr8_re_1_7 0 s1 x8_re_a7 0 89019222.79
Gr8_im_1_7 0 s1 x8_im_a7 0 665897727.2
Gr9_re_1_7 0 s1 x9_re_a7 0 -286282749.4
Gr9_im_1_7 0 s1 x9_im_a7 0 628482473
Gr10_re_1_7 0 s1 x10_re_a7 0 -224554221.2
Gr10_im_1_7 0 s1 x10_im_a7 0 -665736142.3
Cx1_a1 x1_a1 0 0.002631481677
Gx1_a1 0 x1_a1 p1 0 0.0001860738539
Fx1_a1 0 x1_a1 V1 0.009303692693
Rp1_a1 0 x1_a1 1e-09
Cx2_re_a1 x2_re_a1 0 0.002139679567
Gx2_re_a1 0 x2_re_a1 p1 0 0.0003025963863
Fx2_re_a1 0 x2_re_a1 V1 0.01512981932
Rp2_re_re_a1 0 x2_re_a1 1e-09
Gp2_re_im_a1 0 x2_re_a1 x2_im_a1 0 3229635754
Cx2_im_a1 x2_im_a1 0 0.002139679567
Gp2_im_re_a1 0 x2_im_a1 x2_re_a1 0 -3229635754
Rp2_im_im_a1 0 x2_im_a1 1e-09
Cx3_re_a1 x3_re_a1 0 0.002091274299
Gx3_re_a1 0 x3_re_a1 p1 0 0.0002957508476
Fx3_re_a1 0 x3_re_a1 V1 0.01478754238
Rp3_re_re_a1 0 x3_re_a1 1e-09
Gp3_re_im_a1 0 x3_re_a1 x3_im_a1 0 1009553277
Cx3_im_a1 x3_im_a1 0 0.002091274299
Gp3_im_re_a1 0 x3_im_a1 x3_re_a1 0 -1009553277
Rp3_im_im_a1 0 x3_im_a1 1e-09
Cx4_re_a1 x4_re_a1 0 0.01454723191
Gx4_re_a1 0 x4_re_a1 p1 0 0.002057289267
Fx4_re_a1 0 x4_re_a1 V1 0.1028644633
Rp4_re_re_a1 0 x4_re_a1 1e-09
Gp4_re_im_a1 0 x4_re_a1 x4_im_a1 0 1.951471624e+10
Cx4_im_a1 x4_im_a1 0 0.01454723191
Gp4_im_re_a1 0 x4_im_a1 x4_re_a1 0 -1.951471624e+10
Rp4_im_im_a1 0 x4_im_a1 1e-09
Cx5_re_a1 x5_re_a1 0 0.01007230363
Gx5_re_a1 0 x5_re_a1 p1 0 0.00142443884
Fx5_re_a1 0 x5_re_a1 V1 0.07122194198
Rp5_re_re_a1 0 x5_re_a1 1e-09
Gp5_re_im_a1 0 x5_re_a1 x5_im_a1 0 1.183679285e+10
Cx5_im_a1 x5_im_a1 0 0.01007230363
Gp5_im_re_a1 0 x5_im_a1 x5_re_a1 0 -1.183679285e+10
Rp5_im_im_a1 0 x5_im_a1 1e-09
Cx6_re_a1 x6_re_a1 0 0.004969238773
Gx6_re_a1 0 x6_re_a1 p1 0 0.0007027564868
Fx6_re_a1 0 x6_re_a1 V1 0.03513782434
Rp6_re_re_a1 0 x6_re_a1 1e-09
Gp6_re_im_a1 0 x6_re_a1 x6_im_a1 0 5205754834
Cx6_im_a1 x6_im_a1 0 0.004969238773
Gp6_im_re_a1 0 x6_im_a1 x6_re_a1 0 -5205754834
Rp6_im_im_a1 0 x6_im_a1 1e-09
Cx7_re_a1 x7_re_a1 0 0.007093124953
Gx7_re_a1 0 x7_re_a1 p1 0 0.001003119351
Fx7_re_a1 0 x7_re_a1 V1 0.05015596754
Rp7_re_re_a1 0 x7_re_a1 1e-09
Gp7_re_im_a1 0 x7_re_a1 x7_im_a1 0 6261898191
Cx7_im_a1 x7_im_a1 0 0.007093124953
Gp7_im_re_a1 0 x7_im_a1 x7_re_a1 0 -6261898191
Rp7_im_im_a1 0 x7_im_a1 1e-09
Cx8_re_a1 x8_re_a1 0 0.02175510083
Gx8_re_a1 0 x8_re_a1 p1 0 0.003076635864
Fx8_re_a1 0 x8_re_a1 V1 0.1538317932
Rp8_re_re_a1 0 x8_re_a1 1e-09
Gp8_re_im_a1 0 x8_re_a1 x8_im_a1 0 2.327097802e+10
Cx8_im_a1 x8_im_a1 0 0.02175510083
Gp8_im_re_a1 0 x8_im_a1 x8_re_a1 0 -2.327097802e+10
Rp8_im_im_a1 0 x8_im_a1 1e-09
Cx9_re_a1 x9_re_a1 0 0.02772087825
Gx9_re_a1 0 x9_re_a1 p1 0 0.003920324198
Fx9_re_a1 0 x9_re_a1 V1 0.1960162099
Rp9_re_re_a1 0 x9_re_a1 1e-09
Gp9_re_im_a1 0 x9_re_a1 x9_im_a1 0 2.583815977e+10
Cx9_im_a1 x9_im_a1 0 0.02772087825
Gp9_im_re_a1 0 x9_im_a1 x9_re_a1 0 -2.583815977e+10
Rp9_im_im_a1 0 x9_im_a1 1e-09
Cx10_re_a1 x10_re_a1 0 0.02248079784
Gx10_re_a1 0 x10_re_a1 p1 0 0.00317926492
Fx10_re_a1 0 x10_re_a1 V1 0.158963246
Rp10_re_re_a1 0 x10_re_a1 1e-09
Gp10_re_im_a1 0 x10_re_a1 x10_im_a1 0 2.233186075e+10
Cx10_im_a1 x10_im_a1 0 0.02248079784
Gp10_im_re_a1 0 x10_im_a1 x10_re_a1 0 -2.233186075e+10
Rp10_im_im_a1 0 x10_im_a1 1e-09
V2 p2 s2 0
R2 s2 0 50
Gd2_1 0 s2 p1 0 1.900824154e-05
Fd2_1 0 s2 V1 0.0009504120768
Gr1_2_1 0 s2 x1_a1 0 1074839034
Gr2_re_2_1 0 s2 x2_re_a1 0 -326536696
Gr2_im_2_1 0 s2 x2_im_a1 0 -580873251.8
Gr3_re_2_1 0 s2 x3_re_a1 0 -270049937.9
Gr3_im_2_1 0 s2 x3_im_a1 0 959846855.1
Gr4_re_2_1 0 s2 x4_re_a1 0 -83437987.92
Gr4_im_2_1 0 s2 x4_im_a1 0 -1985257.867
Gr5_re_2_1 0 s2 x5_re_a1 0 -603257299
Gr5_im_2_1 0 s2 x5_im_a1 0 176620506.7
Gr6_re_2_1 0 s2 x6_re_a1 0 298493313.4
Gr6_im_2_1 0 s2 x6_im_a1 0 -1288218667
Gr7_re_2_1 0 s2 x7_re_a1 0 608357646.6
Gr7_im_2_1 0 s2 x7_im_a1 0 621600046.8
Gr8_re_2_1 0 s2 x8_re_a1 0 -13535224.1
Gr8_im_2_1 0 s2 x8_im_a1 0 617688457.3
Gr9_re_2_1 0 s2 x9_re_a1 0 -271400550.2
Gr9_im_2_1 0 s2 x9_im_a1 0 598411793.3
Gr10_re_2_1 0 s2 x10_re_a1 0 -237544578.2
Gr10_im_2_1 0 s2 x10_im_a1 0 -538837417.9
Gd2_2 0 s2 p2 0 -0.003292841456
Fd2_2 0 s2 V2 -0.1646420728
Gr1_2_2 0 s2 x1_a2 0 1.077867727e+11
Gr2_re_2_2 0 s2 x2_re_a2 0 -4.396373382e+10
Gr2_im_2_2 0 s2 x2_im_a2 0 -1.094060423e+11
Gr3_re_2_2 0 s2 x3_re_a2 0 -2.077974526e+10
Gr3_im_2_2 0 s2 x3_im_a2 0 1.995668076e+11
Gr4_re_2_2 0 s2 x4_re_a2 0 -316693522.1
Gr4_im_2_2 0 s2 x4_im_a2 0 -609777238.3
Gr5_re_2_2 0 s2 x5_re_a2 0 2929106344
Gr5_im_2_2 0 s2 x5_im_a2 0 -6970083128
Gr6_re_2_2 0 s2 x6_re_a2 0 -5.810721028e+10
Gr6_im_2_2 0 s2 x6_im_a2 0 -2.857008855e+10
Gr7_re_2_2 0 s2 x7_re_a2 0 -1.434571878e+10
Gr7_im_2_2 0 s2 x7_im_a2 0 3.172527228e+10
Gr8_re_2_2 0 s2 x8_re_a2 0 1194242804
Gr8_im_2_2 0 s2 x8_im_a2 0 671591830
Gr9_re_2_2 0 s2 x9_re_a2 0 -415140423.5
Gr9_im_2_2 0 s2 x9_im_a2 0 547067427.6
Gr10_re_2_2 0 s2 x10_re_a2 0 -171997038.9
Gr10_im_2_2 0 s2 x10_im_a2 0 1644491993
Gd2_3 0 s2 p3 0 0.004916721199
Fd2_3 0 s2 V3 0.24583606
Gr1_2_3 0 s2 x1_a3 0 -1.762658616e+11
Gr2_re_2_3 0 s2 x2_re_a3 0 4.149840631e+10
Gr2_im_2_3 0 s2 x2_im_a3 0 -1.420552324e+11
Gr3_re_2_3 0 s2 x3_re_a3 0 -1.23965466e+11
Gr3_im_2_3 0 s2 x3_im_a3 0 -2.526449655e+11
Gr4_re_2_3 0 s2 x4_re_a3 0 -338102623.9
Gr4_im_2_3 0 s2 x4_im_a3 0 1657760796
Gr5_re_2_3 0 s2 x5_re_a3 0 4148409732
Gr5_im_2_3 0 s2 x5_im_a3 0 -2772878298
Gr6_re_2_3 0 s2 x6_re_a3 0 -2.22287264e+10
Gr6_im_2_3 0 s2 x6_im_a3 0 2.757270906e+10
Gr7_re_2_3 0 s2 x7_re_a3 0 1.82220509e+10
Gr7_im_2_3 0 s2 x7_im_a3 0 -9907705145
Gr8_re_2_3 0 s2 x8_re_a3 0 1386884749
Gr8_im_2_3 0 s2 x8_im_a3 0 -79755700.49
Gr9_re_2_3 0 s2 x9_re_a3 0 315330586.8
Gr9_im_2_3 0 s2 x9_im_a3 0 1066780650
Gr10_re_2_3 0 s2 x10_re_a3 0 1181576802
Gr10_im_2_3 0 s2 x10_im_a3 0 1423666187
Gd2_4 0 s2 p4 0 -0.0003915273918
Fd2_4 0 s2 V4 -0.01957636959
Gr1_2_4 0 s2 x1_a4 0 -4.95072765e+10
Gr2_re_2_4 0 s2 x2_re_a4 0 3.307361897e+10
Gr2_im_2_4 0 s2 x2_im_a4 0 9.786553652e+10
Gr3_re_2_4 0 s2 x3_re_a4 0 -3.782012352e+10
Gr3_im_2_4 0 s2 x3_im_a4 0 -1.476859639e+11
Gr4_re_2_4 0 s2 x4_re_a4 0 2787089380
Gr4_im_2_4 0 s2 x4_im_a4 0 -1754558830
Gr5_re_2_4 0 s2 x5_re_a4 0 -454193166.3
Gr5_im_2_4 0 s2 x5_im_a4 0 1507937603
Gr6_re_2_4 0 s2 x6_re_a4 0 6.339801365e+10
Gr6_im_2_4 0 s2 x6_im_a4 0 1.362308682e+10
Gr7_re_2_4 0 s2 x7_re_a4 0 -5631944472
Gr7_im_2_4 0 s2 x7_im_a4 0 -3.762381928e+10
Gr8_re_2_4 0 s2 x8_re_a4 0 -1657959490
Gr8_im_2_4 0 s2 x8_im_a4 0 -939556907.5
Gr9_re_2_4 0 s2 x9_re_a4 0 1054556791
Gr9_im_2_4 0 s2 x9_im_a4 0 -611965632.2
Gr10_re_2_4 0 s2 x10_re_a4 0 607989765.9
Gr10_im_2_4 0 s2 x10_im_a4 0 -2341717047
Gd2_5 0 s2 p5 0 -0.0003132020177
Fd2_5 0 s2 V5 -0.01566010089
Gr1_2_5 0 s2 x1_a5 0 -7.093938185e+10
Gr2_re_2_5 0 s2 x2_re_a5 0 -9913224695
Gr2_im_2_5 0 s2 x2_im_a5 0 1.004639139e+11
Gr3_re_2_5 0 s2 x3_re_a5 0 -6.906249187e+10
Gr3_im_2_5 0 s2 x3_im_a5 0 -1.988507169e+11
Gr4_re_2_5 0 s2 x4_re_a5 0 -55772583
Gr4_im_2_5 0 s2 x4_im_a5 0 1452367952
Gr5_re_2_5 0 s2 x5_re_a5 0 1601409469
Gr5_im_2_5 0 s2 x5_im_a5 0 3169204003
Gr6_re_2_5 0 s2 x6_re_a5 0 1.102939518e+11
Gr6_im_2_5 0 s2 x6_im_a5 0 1.322230057e+10
Gr7_re_2_5 0 s2 x7_re_a5 0 1.474123702e+10
Gr7_im_2_5 0 s2 x7_im_a5 0 -2.929430994e+10
Gr8_re_2_5 0 s2 x8_re_a5 0 -575956396.8
Gr8_im_2_5 0 s2 x8_im_a5 0 -783626730.2
Gr9_re_2_5 0 s2 x9_re_a5 0 565380526.5
Gr9_im_2_5 0 s2 x9_im_a5 0 -237744823.7
Gr10_re_2_5 0 s2 x10_re_a5 0 677806445.4
Gr10_im_2_5 0 s2 x10_im_a5 0 -1323082282
Gd2_6 0 s2 p6 0 0.003265681578
Fd2_6 0 s2 V6 0.1632840789
Gr1_2_6 0 s2 x1_a6 0 -6.712289382e+10
Gr2_re_2_6 0 s2 x2_re_a6 0 4.86257948e+10
Gr2_im_2_6 0 s2 x2_im_a6 0 -9.546178556e+10
Gr3_re_2_6 0 s2 x3_re_a6 0 -1.451330149e+11
Gr3_im_2_6 0 s2 x3_im_a6 0 -1.520132409e+11
Gr4_re_2_6 0 s2 x4_re_a6 0 1649529386
Gr4_im_2_6 0 s2 x4_im_a6 0 -1506428120
Gr5_re_2_6 0 s2 x5_re_a6 0 -1105878299
Gr5_im_2_6 0 s2 x5_im_a6 0 -5708740881
Gr6_re_2_6 0 s2 x6_re_a6 0 2.1540902e+10
Gr6_im_2_6 0 s2 x6_im_a6 0 2.606048053e+10
Gr7_re_2_6 0 s2 x7_re_a6 0 -9776177864
Gr7_im_2_6 0 s2 x7_im_a6 0 -3.24841559e+10
Gr8_re_2_6 0 s2 x8_re_a6 0 -302735091.9
Gr8_im_2_6 0 s2 x8_im_a6 0 -844446673.4
Gr9_re_2_6 0 s2 x9_re_a6 0 807004273.9
Gr9_im_2_6 0 s2 x9_im_a6 0 -167471043.1
Gr10_re_2_6 0 s2 x10_re_a6 0 727129250.7
Gr10_im_2_6 0 s2 x10_im_a6 0 -934337473.6
Gd2_7 0 s2 p7 0 -0.002316618277
Fd2_7 0 s2 V7 -0.1158309139
Gr1_2_7 0 s2 x1_a7 0 1.770309783e+11
Gr2_re_2_7 0 s2 x2_re_a7 0 -1.002646187e+11
Gr2_im_2_7 0 s2 x2_im_a7 0 2.10763558e+10
Gr3_re_2_7 0 s2 x3_re_a7 0 1.009373731e+11
Gr3_im_2_7 0 s2 x3_im_a7 0 1.990752319e+11
Gr4_re_2_7 0 s2 x4_re_a7 0 -185137221.7
Gr4_im_2_7 0 s2 x4_im_a7 0 -1297618616
Gr5_re_2_7 0 s2 x5_re_a7 0 3055995042
Gr5_im_2_7 0 s2 x5_im_a7 0 -1227961273
Gr6_re_2_7 0 s2 x6_re_a7 0 210901260.5
Gr6_im_2_7 0 s2 x6_im_a7 0 6412350870
Gr7_re_2_7 0 s2 x7_re_a7 0 -2.665920847e+10
Gr7_im_2_7 0 s2 x7_im_a7 0 8408770782
Gr8_re_2_7 0 s2 x8_re_a7 0 -428442087.7
Gr8_im_2_7 0 s2 x8_im_a7 0 696905269.2
Gr9_re_2_7 0 s2 x9_re_a7 0 -645850171.1
Gr9_im_2_7 0 s2 x9_im_a7 0 -672920013.1
Gr10_re_2_7 0 s2 x10_re_a7 0 -1470378265
Gr10_im_2_7 0 s2 x10_im_a7 0 -250740435.5
Cx1_a2 x1_a2 0 0.002631481677
Gx1_a2 0 x1_a2 p2 0 0.0001860738539
Fx1_a2 0 x1_a2 V2 0.009303692693
Rp1_a2 0 x1_a2 1e-09
Cx2_re_a2 x2_re_a2 0 0.002139679567
Gx2_re_a2 0 x2_re_a2 p2 0 0.0003025963863
Fx2_re_a2 0 x2_re_a2 V2 0.01512981932
Rp2_re_re_a2 0 x2_re_a2 1e-09
Gp2_re_im_a2 0 x2_re_a2 x2_im_a2 0 3229635754
Cx2_im_a2 x2_im_a2 0 0.002139679567
Gp2_im_re_a2 0 x2_im_a2 x2_re_a2 0 -3229635754
Rp2_im_im_a2 0 x2_im_a2 1e-09
Cx3_re_a2 x3_re_a2 0 0.002091274299
Gx3_re_a2 0 x3_re_a2 p2 0 0.0002957508476
Fx3_re_a2 0 x3_re_a2 V2 0.01478754238
Rp3_re_re_a2 0 x3_re_a2 1e-09
Gp3_re_im_a2 0 x3_re_a2 x3_im_a2 0 1009553277
Cx3_im_a2 x3_im_a2 0 0.002091274299
Gp3_im_re_a2 0 x3_im_a2 x3_re_a2 0 -1009553277
Rp3_im_im_a2 0 x3_im_a2 1e-09
Cx4_re_a2 x4_re_a2 0 0.01454723191
Gx4_re_a2 0 x4_re_a2 p2 0 0.002057289267
Fx4_re_a2 0 x4_re_a2 V2 0.1028644633
Rp4_re_re_a2 0 x4_re_a2 1e-09
Gp4_re_im_a2 0 x4_re_a2 x4_im_a2 0 1.951471624e+10
Cx4_im_a2 x4_im_a2 0 0.01454723191
Gp4_im_re_a2 0 x4_im_a2 x4_re_a2 0 -1.951471624e+10
Rp4_im_im_a2 0 x4_im_a2 1e-09
Cx5_re_a2 x5_re_a2 0 0.01007230363
Gx5_re_a2 0 x5_re_a2 p2 0 0.00142443884
Fx5_re_a2 0 x5_re_a2 V2 0.07122194198
Rp5_re_re_a2 0 x5_re_a2 1e-09
Gp5_re_im_a2 0 x5_re_a2 x5_im_a2 0 1.183679285e+10
Cx5_im_a2 x5_im_a2 0 0.01007230363
Gp5_im_re_a2 0 x5_im_a2 x5_re_a2 0 -1.183679285e+10
Rp5_im_im_a2 0 x5_im_a2 1e-09
Cx6_re_a2 x6_re_a2 0 0.004969238773
Gx6_re_a2 0 x6_re_a2 p2 0 0.0007027564868
Fx6_re_a2 0 x6_re_a2 V2 0.03513782434
Rp6_re_re_a2 0 x6_re_a2 1e-09
Gp6_re_im_a2 0 x6_re_a2 x6_im_a2 0 5205754834
Cx6_im_a2 x6_im_a2 0 0.004969238773
Gp6_im_re_a2 0 x6_im_a2 x6_re_a2 0 -5205754834
Rp6_im_im_a2 0 x6_im_a2 1e-09
Cx7_re_a2 x7_re_a2 0 0.007093124953
Gx7_re_a2 0 x7_re_a2 p2 0 0.001003119351
Fx7_re_a2 0 x7_re_a2 V2 0.05015596754
Rp7_re_re_a2 0 x7_re_a2 1e-09
Gp7_re_im_a2 0 x7_re_a2 x7_im_a2 0 6261898191
Cx7_im_a2 x7_im_a2 0 0.007093124953
Gp7_im_re_a2 0 x7_im_a2 x7_re_a2 0 -6261898191
Rp7_im_im_a2 0 x7_im_a2 1e-09
Cx8_re_a2 x8_re_a2 0 0.02175510083
Gx8_re_a2 0 x8_re_a2 p2 0 0.003076635864
Fx8_re_a2 0 x8_re_a2 V2 0.1538317932
Rp8_re_re_a2 0 x8_re_a2 1e-09
Gp8_re_im_a2 0 x8_re_a2 x8_im_a2 0 2.327097802e+10
Cx8_im_a2 x8_im_a2 0 0.02175510083
Gp8_im_re_a2 0 x8_im_a2 x8_re_a2 0 -2.327097802e+10
Rp8_im_im_a2 0 x8_im_a2 1e-09
Cx9_re_a2 x9_re_a2 0 0.02772087825
Gx9_re_a2 0 x9_re_a2 p2 0 0.003920324198
Fx9_re_a2 0 x9_re_a2 V2 0.1960162099
Rp9_re_re_a2 0 x9_re_a2 1e-09
Gp9_re_im_a2 0 x9_re_a2 x9_im_a2 0 2.583815977e+10
Cx9_im_a2 x9_im_a2 0 0.02772087825
Gp9_im_re_a2 0 x9_im_a2 x9_re_a2 0 -2.583815977e+10
Rp9_im_im_a2 0 x9_im_a2 1e-09
Cx10_re_a2 x10_re_a2 0 0.02248079784
Gx10_re_a2 0 x10_re_a2 p2 0 0.00317926492
Fx10_re_a2 0 x10_re_a2 V2 0.158963246
Rp10_re_re_a2 0 x10_re_a2 1e-09
Gp10_re_im_a2 0 x10_re_a2 x10_im_a2 0 2.233186075e+10
Cx10_im_a2 x10_im_a2 0 0.02248079784
Gp10_im_re_a2 0 x10_im_a2 x10_re_a2 0 -2.233186075e+10
Rp10_im_im_a2 0 x10_im_a2 1e-09
V3 p3 s3 0
R3 s3 0 50
Gd3_1 0 s3 p1 0 -0.0002332803341
Fd3_1 0 s3 V1 -0.0116640167
Gr1_3_1 0 s3 x1_a1 0 43870248.19
Gr2_re_3_1 0 s3 x2_re_a1 0 -3268310228
Gr2_im_3_1 0 s3 x2_im_a1 0 5305231646
Gr3_re_3_1 0 s3 x3_re_a1 0 3851176442
Gr3_im_3_1 0 s3 x3_im_a1 0 -2119736623
Gr4_re_3_1 0 s3 x4_re_a1 0 6854712.759
Gr4_im_3_1 0 s3 x4_im_a1 0 39940758.82
Gr5_re_3_1 0 s3 x5_re_a1 0 -883594795.9
Gr5_im_3_1 0 s3 x5_im_a1 0 -2315631646
Gr6_re_3_1 0 s3 x6_re_a1 0 1.130218465e+10
Gr6_im_3_1 0 s3 x6_im_a1 0 1.066906102e+10
Gr7_re_3_1 0 s3 x7_re_a1 0 -2309672730
Gr7_im_3_1 0 s3 x7_im_a1 0 -3221858727
Gr8_re_3_1 0 s3 x8_re_a1 0 -3044053731
Gr8_im_3_1 0 s3 x8_im_a1 0 -2302185939
Gr9_re_3_1 0 s3 x9_re_a1 0 246491235.3
Gr9_im_3_1 0 s3 x9_im_a1 0 -1782859184
Gr10_re_3_1 0 s3 x10_re_a1 0 543493771.5
Gr10_im_3_1 0 s3 x10_im_a1 0 2212433741
Gd3_2 0 s3 p2 0 0.004916721199
Fd3_2 0 s3 V2 0.24583606
Gr1_3_2 0 s3 x1_a2 0 -1.762658616e+11
Gr2_re_3_2 0 s3 x2_re_a2 0 4.14984063e+10
Gr2_im_3_2 0 s3 x2_im_a2 0 -1.420552324e+11
Gr3_re_3_2 0 s3 x3_re_a2 0 -1.23965466e+11
Gr3_im_3_2 0 s3 x3_im_a2 0 -2.526449655e+11
Gr4_re_3_2 0 s3 x4_re_a2 0 -338102624
Gr4_im_3_2 0 s3 x4_im_a2 0 1657760796
Gr5_re_3_2 0 s3 x5_re_a2 0 4148409732
Gr5_im_3_2 0 s3 x5_im_a2 0 -2772878299
Gr6_re_3_2 0 s3 x6_re_a2 0 -2.22287264e+10
Gr6_im_3_2 0 s3 x6_im_a2 0 2.757270907e+10
Gr7_re_3_2 0 s3 x7_re_a2 0 1.82220509e+10
Gr7_im_3_2 0 s3 x7_im_a2 0 -9907705146
Gr8_re_3_2 0 s3 x8_re_a2 0 1386884749
Gr8_im_3_2 0 s3 x8_im_a2 0 -79755700.57
Gr9_re_3_2 0 s3 x9_re_a2 0 315330586.9
Gr9_im_3_2 0 s3 x9_im_a2 0 1066780650
Gr10_re_3_2 0 s3 x10_re_a2 0 1181576803
Gr10_im_3_2 0 s3 x10_im_a2 0 1423666187
Gd3_3 0 s3 p3 0 -0.005833465692
Fd3_3 0 s3 V3 -0.2916732846
Gr1_3_3 0 s3 x1_a3 0 -1.286793537e+11
Gr2_re_3_3 0 s3 x2_re_a3 0 3.40028036e+10
Gr2_im_3_3 0 s3 x2_im_a3 0 -7847739373
Gr3_re_3_3 0 s3 x3_re_a3 0 3.362275123e+10
Gr3_im_3_3 0 s3 x3_im_a3 0 -4.764227757e+10
Gr4_re_3_3 0 s3 x4_re_a3 0 1466587830
Gr4_im_3_3 0 s3 x4_im_a3 0 -5019672452
Gr5_re_3_3 0 s3 x5_re_a3 0 6542230770
Gr5_im_3_3 0 s3 x5_im_a3 0 5963207152
Gr6_re_3_3 0 s3 x6_re_a3 0 -2.243475687e+10
Gr6_im_3_3 0 s3 x6_im_a3 0 -8.684614662e+10
Gr7_re_3_3 0 s3 x7_re_a3 0 -1.303899568e+10
Gr7_im_3_3 0 s3 x7_im_a3 0 4.765794378e+10
Gr8_re_3_3 0 s3 x8_re_a3 0 1663728929
Gr8_im_3_3 0 s3 x8_im_a3 0 3952617885
Gr9_re_3_3 0 s3 x9_re_a3 0 -1347457618
Gr9_im_3_3 0 s3 x9_im_a3 0 1019432566
Gr10_re_3_3 0 s3 x10_re_a3 0 -2411013522
Gr10_im_3_3 0 s3 x10_im_a3 0 3706150698
Gd3_4 0 s3 p4 0 0.004340138911
Fd3_4 0 s3 V4 0.2170069455
Gr1_3_4 0 s3 x1_a4 0 -1.010178678e+11
Gr2_re_3_4 0 s3 x2_re_a4 0 -5.026512835e+10
Gr2_im_3_4 0 s3 x2_im_a4 0 -1.467187283e+11
Gr3_re_3_4 0 s3 x3_re_a4 0 5.511846727e+10
Gr3_im_3_4 0 s3 x3_im_a4 0 -6.517198926e+10
Gr4_re_3_4 0 s3 x4_re_a4 0 -3563759003
Gr4_im_3_4 0 s3 x4_im_a4 0 1849091600
Gr5_re_3_4 0 s3 x5_re_a4 0 2.614374003e+10
Gr5_im_3_4 0 s3 x5_im_a4 0 -3098218088
Gr6_re_3_4 0 s3 x6_re_a4 0 -1.476863956e+11
Gr6_im_3_4 0 s3 x6_im_a4 0 -3.686528887e+10
Gr7_re_3_4 0 s3 x7_re_a4 0 2.590605531e+10
Gr7_im_3_4 0 s3 x7_im_a4 0 6.196159176e+10
Gr8_re_3_4 0 s3 x8_re_a4 0 5289085071
Gr8_im_3_4 0 s3 x8_im_a4 0 2257336743
Gr9_re_3_4 0 s3 x9_re_a4 0 -1355658430
Gr9_im_3_4 0 s3 x9_im_a4 0 2611045069
Gr10_re_3_4 0 s3 x10_re_a4 0 321181528.8
Gr10_im_3_4 0 s3 x10_im_a4 0 6701694566
Gd3_5 0 s3 p5 0 -0.007149869514
Fd3_5 0 s3 V5 -0.3574934757
Gr1_3_5 0 s3 x1_a5 0 2.503384884e+11
Gr2_re_3_5 0 s3 x2_re_a5 0 5588310651
Gr2_im_3_5 0 s3 x2_im_a5 0 1.748417736e+11
Gr3_re_3_5 0 s3 x3_re_a5 0 1.857748865e+10
Gr3_im_3_5 0 s3 x3_im_a5 0 2.091604241e+11
Gr4_re_3_5 0 s3 x4_re_a5 0 -3614630.237
Gr4_im_3_5 0 s3 x4_im_a5 0 -3080912456
Gr5_re_3_5 0 s3 x5_re_a5 0 -8500813468
Gr5_im_3_5 0 s3 x5_im_a5 0 1.634807445e+10
Gr6_re_3_5 0 s3 x6_re_a5 0 1.092387688e+11
Gr6_im_3_5 0 s3 x6_im_a5 0 -6.598674704e+10
Gr7_re_3_5 0 s3 x7_re_a5 0 -4.334837746e+10
Gr7_im_3_5 0 s3 x7_im_a5 0 4453865048
Gr8_re_3_5 0 s3 x8_re_a5 0 -2908680516
Gr8_im_3_5 0 s3 x8_im_a5 0 1155576252
Gr9_re_3_5 0 s3 x9_re_a5 0 -1391425967
Gr9_im_3_5 0 s3 x9_im_a5 0 -2410533328
Gr10_re_3_5 0 s3 x10_re_a5 0 -3879366949
Gr10_im_3_5 0 s3 x10_im_a5 0 -2680213523
Gd3_6 0 s3 p6 0 0.002908189119
Fd3_6 0 s3 V6 0.1454094559
Gr1_3_6 0 s3 x1_a6 0 1.884440655e+11
Gr2_re_3_6 0 s3 x2_re_a6 0 -2.07376733e+10
Gr2_im_3_6 0 s3 x2_im_a6 0 -1.043000243e+11
Gr3_re_3_6 0 s3 x3_re_a6 0 -6.895718342e+10
Gr3_im_3_6 0 s3 x3_im_a6 0 1.827797252e+11
Gr4_re_3_6 0 s3 x4_re_a6 0 -4294062344
Gr4_im_3_6 0 s3 x4_im_a6 0 5038415336
Gr5_re_3_6 0 s3 x5_re_a6 0 1.347298872e+10
Gr5_im_3_6 0 s3 x5_im_a6 0 3023307423
Gr6_re_3_6 0 s3 x6_re_a6 0 -1.027906239e+11
Gr6_im_3_6 0 s3 x6_im_a6 0 -4.989053277e+10
Gr7_re_3_6 0 s3 x7_re_a6 0 1.525394698e+10
Gr7_im_3_6 0 s3 x7_im_a6 0 4.282563373e+10
Gr8_re_3_6 0 s3 x8_re_a6 0 1604594315
Gr8_im_3_6 0 s3 x8_im_a6 0 3485537.939
Gr9_re_3_6 0 s3 x9_re_a6 0 -1175107936
Gr9_im_3_6 0 s3 x9_im_a6 0 246296592.2
Gr10_re_3_6 0 s3 x10_re_a6 0 -374914122.7
Gr10_im_3_6 0 s3 x10_im_a6 0 1655723216
Gd3_7 0 s3 p7 0 -0.0005371468312
Fd3_7 0 s3 V7 -0.02685734156
Gr1_3_7 0 s3 x1_a7 0 -6.155342671e+10
Gr2_re_3_7 0 s3 x2_re_a7 0 -1.001442867e+10
Gr2_im_3_7 0 s3 x2_im_a7 0 1.038114939e+11
Gr3_re_3_7 0 s3 x3_re_a7 0 -6.71741821e+10
Gr3_im_3_7 0 s3 x3_im_a7 0 -1.901733806e+11
Gr4_re_3_7 0 s3 x4_re_a7 0 -402530772.6
Gr4_im_3_7 0 s3 x4_im_a7 0 1275671142
Gr5_re_3_7 0 s3 x5_re_a7 0 1514209730
Gr5_im_3_7 0 s3 x5_im_a7 0 3445509827
Gr6_re_3_7 0 s3 x6_re_a7 0 1.110336944e+11
Gr6_im_3_7 0 s3 x6_im_a7 0 1.329135452e+10
Gr7_re_3_7 0 s3 x7_re_a7 0 1.421600913e+10
Gr7_im_3_7 0 s3 x7_im_a7 0 -2.90640721e+10
Gr8_re_3_7 0 s3 x8_re_a7 0 -611147542.6
Gr8_im_3_7 0 s3 x8_im_a7 0 -813285361.5
Gr9_re_3_7 0 s3 x9_re_a7 0 547353835.9
Gr9_im_3_7 0 s3 x9_im_a7 0 -297730651.3
Gr10_re_3_7 0 s3 x10_re_a7 0 637127669.9
Gr10_im_3_7 0 s3 x10_im_a7 0 -1394800095
Cx1_a3 x1_a3 0 0.002631481677
Gx1_a3 0 x1_a3 p3 0 0.0001860738539
Fx1_a3 0 x1_a3 V3 0.009303692693
Rp1_a3 0 x1_a3 1e-09
Cx2_re_a3 x2_re_a3 0 0.002139679567
Gx2_re_a3 0 x2_re_a3 p3 0 0.0003025963863
Fx2_re_a3 0 x2_re_a3 V3 0.01512981932
Rp2_re_re_a3 0 x2_re_a3 1e-09
Gp2_re_im_a3 0 x2_re_a3 x2_im_a3 0 3229635754
Cx2_im_a3 x2_im_a3 0 0.002139679567
Gp2_im_re_a3 0 x2_im_a3 x2_re_a3 0 -3229635754
Rp2_im_im_a3 0 x2_im_a3 1e-09
Cx3_re_a3 x3_re_a3 0 0.002091274299
Gx3_re_a3 0 x3_re_a3 p3 0 0.0002957508476
Fx3_re_a3 0 x3_re_a3 V3 0.01478754238
Rp3_re_re_a3 0 x3_re_a3 1e-09
Gp3_re_im_a3 0 x3_re_a3 x3_im_a3 0 1009553277
Cx3_im_a3 x3_im_a3 0 0.002091274299
Gp3_im_re_a3 0 x3_im_a3 x3_re_a3 0 -1009553277
Rp3_im_im_a3 0 x3_im_a3 1e-09
Cx4_re_a3 x4_re_a3 0 0.01454723191
Gx4_re_a3 0 x4_re_a3 p3 0 0.002057289267
Fx4_re_a3 0 x4_re_a3 V3 0.1028644633
Rp4_re_re_a3 0 x4_re_a3 1e-09
Gp4_re_im_a3 0 x4_re_a3 x4_im_a3 0 1.951471624e+10
Cx4_im_a3 x4_im_a3 0 0.01454723191
Gp4_im_re_a3 0 x4_im_a3 x4_re_a3 0 -1.951471624e+10
Rp4_im_im_a3 0 x4_im_a3 1e-09
Cx5_re_a3 x5_re_a3 0 0.01007230363
Gx5_re_a3 0 x5_re_a3 p3 0 0.00142443884
Fx5_re_a3 0 x5_re_a3 V3 0.07122194198
Rp5_re_re_a3 0 x5_re_a3 1e-09
Gp5_re_im_a3 0 x5_re_a3 x5_im_a3 0 1.183679285e+10
Cx5_im_a3 x5_im_a3 0 0.01007230363
Gp5_im_re_a3 0 x5_im_a3 x5_re_a3 0 -1.183679285e+10
Rp5_im_im_a3 0 x5_im_a3 1e-09
Cx6_re_a3 x6_re_a3 0 0.004969238773
Gx6_re_a3 0 x6_re_a3 p3 0 0.0007027564868
Fx6_re_a3 0 x6_re_a3 V3 0.03513782434
Rp6_re_re_a3 0 x6_re_a3 1e-09
Gp6_re_im_a3 0 x6_re_a3 x6_im_a3 0 5205754834
Cx6_im_a3 x6_im_a3 0 0.004969238773
Gp6_im_re_a3 0 x6_im_a3 x6_re_a3 0 -5205754834
Rp6_im_im_a3 0 x6_im_a3 1e-09
Cx7_re_a3 x7_re_a3 0 0.007093124953
Gx7_re_a3 0 x7_re_a3 p3 0 0.001003119351
Fx7_re_a3 0 x7_re_a3 V3 0.05015596754
Rp7_re_re_a3 0 x7_re_a3 1e-09
Gp7_re_im_a3 0 x7_re_a3 x7_im_a3 0 6261898191
Cx7_im_a3 x7_im_a3 0 0.007093124953
Gp7_im_re_a3 0 x7_im_a3 x7_re_a3 0 -6261898191
Rp7_im_im_a3 0 x7_im_a3 1e-09
Cx8_re_a3 x8_re_a3 0 0.02175510083
Gx8_re_a3 0 x8_re_a3 p3 0 0.003076635864
Fx8_re_a3 0 x8_re_a3 V3 0.1538317932
Rp8_re_re_a3 0 x8_re_a3 1e-09
Gp8_re_im_a3 0 x8_re_a3 x8_im_a3 0 2.327097802e+10
Cx8_im_a3 x8_im_a3 0 0.02175510083
Gp8_im_re_a3 0 x8_im_a3 x8_re_a3 0 -2.327097802e+10
Rp8_im_im_a3 0 x8_im_a3 1e-09
Cx9_re_a3 x9_re_a3 0 0.02772087825
Gx9_re_a3 0 x9_re_a3 p3 0 0.003920324198
Fx9_re_a3 0 x9_re_a3 V3 0.1960162099
Rp9_re_re_a3 0 x9_re_a3 1e-09
Gp9_re_im_a3 0 x9_re_a3 x9_im_a3 0 2.583815977e+10
Cx9_im_a3 x9_im_a3 0 0.02772087825
Gp9_im_re_a3 0 x9_im_a3 x9_re_a3 0 -2.583815977e+10
Rp9_im_im_a3 0 x9_im_a3 1e-09
Cx10_re_a3 x10_re_a3 0 0.02248079784
Gx10_re_a3 0 x10_re_a3 p3 0 0.00317926492
Fx10_re_a3 0 x10_re_a3 V3 0.158963246
Rp10_re_re_a3 0 x10_re_a3 1e-09
Gp10_re_im_a3 0 x10_re_a3 x10_im_a3 0 2.233186075e+10
Cx10_im_a3 x10_im_a3 0 0.02248079784
Gp10_im_re_a3 0 x10_im_a3 x10_re_a3 0 -2.233186075e+10
Rp10_im_im_a3 0 x10_im_a3 1e-09
V4 p4 s4 0
R4 s4 0 50
Gd4_1 0 s4 p1 0 5.026459992e-05
Fd4_1 0 s4 V1 0.002513229996
Gr1_4_1 0 s4 x1_a1 0 -7574783094
Gr2_re_4_1 0 s4 x2_re_a1 0 4390108420
Gr2_im_4_1 0 s4 x2_im_a1 0 801614958.7
Gr3_re_4_1 0 s4 x3_re_a1 0 -7428957218
Gr3_im_4_1 0 s4 x3_im_a1 0 -8045828079
Gr4_re_4_1 0 s4 x4_re_a1 0 -120484477.9
Gr4_im_4_1 0 s4 x4_im_a1 0 -12627712.37
Gr5_re_4_1 0 s4 x5_re_a1 0 -3663575277
Gr5_im_4_1 0 s4 x5_im_a1 0 1031670450
Gr6_re_4_1 0 s4 x6_re_a1 0 1.387560307e+10
Gr6_im_4_1 0 s4 x6_im_a1 0 -1.325491018e+10
Gr7_re_4_1 0 s4 x7_re_a1 0 -4599842354
Gr7_im_4_1 0 s4 x7_im_a1 0 2670766441
Gr8_re_4_1 0 s4 x8_re_a1 0 -2999865371
Gr8_im_4_1 0 s4 x8_im_a1 0 3855892052
Gr9_re_4_1 0 s4 x9_re_a1 0 -2119281639
Gr9_im_4_1 0 s4 x9_im_a1 0 -774463367.2
Gr10_re_4_1 0 s4 x10_re_a1 0 2993127970
Gr10_im_4_1 0 s4 x10_im_a1 0 -299915233.2
Gd4_2 0 s4 p2 0 -0.0003915273918
Fd4_2 0 s4 V2 -0.01957636959
Gr1_4_2 0 s4 x1_a2 0 -4.95072765e+10
Gr2_re_4_2 0 s4 x2_re_a2 0 3.307361897e+10
Gr2_im_4_2 0 s4 x2_im_a2 0 9.786553652e+10
Gr3_re_4_2 0 s4 x3_re_a2 0 -3.782012351e+10
Gr3_im_4_2 0 s4 x3_im_a2 0 -1.476859639e+11
Gr4_re_4_2 0 s4 x4_re_a2 0 2787089380
Gr4_im_4_2 0 s4 x4_im_a2 0 -1754558830
Gr5_re_4_2 0 s4 x5_re_a2 0 -454193166.6
Gr5_im_4_2 0 s4 x5_im_a2 0 1507937603
Gr6_re_4_2 0 s4 x6_re_a2 0 6.339801365e+10
Gr6_im_4_2 0 s4 x6_im_a2 0 1.362308682e+10
Gr7_re_4_2 0 s4 x7_re_a2 0 -5631944472
Gr7_im_4_2 0 s4 x7_im_a2 0 -3.762381929e+10
Gr8_re_4_2 0 s4 x8_re_a2 0 -1657959490
Gr8_im_4_2 0 s4 x8_im_a2 0 -939556907.6
Gr9_re_4_2 0 s4 x9_re_a2 0 1054556791
Gr9_im_4_2 0 s4 x9_im_a2 0 -611965632.3
Gr10_re_4_2 0 s4 x10_re_a2 0 607989765.9
Gr10_im_4_2 0 s4 x10_im_a2 0 -2341717047
Gd4_3 0 s4 p3 0 0.004340138911
Fd4_3 0 s4 V3 0.2170069455
Gr1_4_3 0 s4 x1_a3 0 -1.010178678e+11
Gr2_re_4_3 0 s4 x2_re_a3 0 -5.026512835e+10
Gr2_im_4_3 0 s4 x2_im_a3 0 -1.467187283e+11
Gr3_re_4_3 0 s4 x3_re_a3 0 5.511846727e+10
Gr3_im_4_3 0 s4 x3_im_a3 0 -6.517198926e+10
Gr4_re_4_3 0 s4 x4_re_a3 0 -3563759003
Gr4_im_4_3 0 s4 x4_im_a3 0 1849091600
Gr5_re_4_3 0 s4 x5_re_a3 0 2.614374003e+10
Gr5_im_4_3 0 s4 x5_im_a3 0 -3098218088
Gr6_re_4_3 0 s4 x6_re_a3 0 -1.476863956e+11
Gr6_im_4_3 0 s4 x6_im_a3 0 -3.686528887e+10
Gr7_re_4_3 0 s4 x7_re_a3 0 2.590605531e+10
Gr7_im_4_3 0 s4 x7_im_a3 0 6.196159176e+10
Gr8_re_4_3 0 s4 x8_re_a3 0 5289085070
Gr8_im_4_3 0 s4 x8_im_a3 0 2257336743
Gr9_re_4_3 0 s4 x9_re_a3 0 -1355658430
Gr9_im_4_3 0 s4 x9_im_a3 0 2611045070
Gr10_re_4_3 0 s4 x10_re_a3 0 321181528.7
Gr10_im_4_3 0 s4 x10_im_a3 0 6701694566
Gd4_4 0 s4 p4 0 -0.00579657357
Fd4_4 0 s4 V4 -0.2898286785
Gr1_4_4 0 s4 x1_a4 0 -5.352184693e+10
Gr2_re_4_4 0 s4 x2_re_a4 0 -6.934655406e+10
Gr2_im_4_4 0 s4 x2_im_a4 0 -5626287928
Gr3_re_4_4 0 s4 x3_re_a4 0 8.572254503e+10
Gr3_im_4_4 0 s4 x3_im_a4 0 -2.970481797e+10
Gr4_re_4_4 0 s4 x4_re_a4 0 7501349717
Gr4_im_4_4 0 s4 x4_im_a4 0 -2764013270
Gr5_re_4_4 0 s4 x5_re_a4 0 8303644473
Gr5_im_4_4 0 s4 x5_im_a4 0 -3.065001056e+10
Gr6_re_4_4 0 s4 x6_re_a4 0 -9.77005521e+10
Gr6_im_4_4 0 s4 x6_im_a4 0 1.066742103e+11
Gr7_re_4_4 0 s4 x7_re_a4 0 8.375309883e+10
Gr7_im_4_4 0 s4 x7_im_a4 0 1.134132539e+10
Gr8_re_4_4 0 s4 x8_re_a4 0 2461032331
Gr8_im_4_4 0 s4 x8_im_a4 0 -3105306882
Gr9_re_4_4 0 s4 x9_re_a4 0 1116837994
Gr9_im_4_4 0 s4 x9_im_a4 0 2766726286
Gr10_re_4_4 0 s4 x10_re_a4 0 5074329597
Gr10_im_4_4 0 s4 x10_im_a4 0 2483488293
Gd4_5 0 s4 p5 0 0.00304860593
Fd4_5 0 s4 V5 0.1524302965
Gr1_4_5 0 s4 x1_a5 0 1.842970854e+11
Gr2_re_4_5 0 s4 x2_re_a5 0 -2.078206713e+10
Gr2_im_4_5 0 s4 x2_im_a5 0 -1.064697694e+11
Gr3_re_4_5 0 s4 x3_re_a5 0 -7.022731538e+10
Gr3_im_4_5 0 s4 x3_im_a5 0 1.790315172e+11
Gr4_re_4_5 0 s4 x4_re_a5 0 -4084131072
Gr4_im_4_5 0 s4 x4_im_a5 0 5153231831
Gr5_re_4_5 0 s4 x5_re_a5 0 1.378648454e+10
Gr5_im_4_5 0 s4 x5_im_a5 0 2943397894
Gr6_re_4_5 0 s4 x6_re_a5 0 -1.042198863e+11
Gr6_im_4_5 0 s4 x6_im_a5 0 -5.050492772e+10
Gr7_re_4_5 0 s4 x7_re_a5 0 1.572755061e+10
Gr7_im_4_5 0 s4 x7_im_a5 0 4.298004517e+10
Gr8_re_4_5 0 s4 x8_re_a5 0 1664694972
Gr8_im_4_5 0 s4 x8_im_a5 0 28068512.02
Gr9_re_4_5 0 s4 x9_re_a5 0 -1157119650
Gr9_im_4_5 0 s4 x9_im_a5 0 297630857.4
Gr10_re_4_5 0 s4 x10_re_a5 0 -344282868.2
Gr10_im_4_5 0 s4 x10_im_a5 0 1741806719
Gd4_6 0 s4 p6 0 -0.004226562547
Fd4_6 0 s4 V6 -0.2113281273
Gr1_4_6 0 s4 x1_a6 0 2.556921973e+11
Gr2_re_4_6 0 s4 x2_re_a6 0 -1.037008055e+11
Gr2_im_4_6 0 s4 x2_im_a6 0 5.942874271e+10
Gr3_re_4_6 0 s4 x3_re_a6 0 9.677427335e+10
Gr3_im_4_6 0 s4 x3_im_a6 0 1.97597291e+11
Gr4_re_4_6 0 s4 x4_re_a6 0 7160951851
Gr4_im_4_6 0 s4 x4_im_a6 0 -776966395.3
Gr5_re_4_6 0 s4 x5_re_a6 0 -5262409854
Gr5_im_4_6 0 s4 x5_im_a6 0 -2.358788893e+10
Gr6_re_4_6 0 s4 x6_re_a6 0 -4.066638358e+10
Gr6_im_4_6 0 s4 x6_im_a6 0 1.730059456e+11
Gr7_re_4_6 0 s4 x7_re_a6 0 5.807362431e+10
Gr7_im_4_6 0 s4 x7_im_a6 0 -3.082750107e+10
Gr8_re_4_6 0 s4 x8_re_a6 0 -1290673156
Gr8_im_4_6 0 s4 x8_im_a6 0 -4488042838
Gr9_re_4_6 0 s4 x9_re_a6 0 547510251.1
Gr9_im_4_6 0 s4 x9_im_a6 0 -86036492.52
Gr10_re_4_6 0 s4 x10_re_a6 0 2717466546
Gr10_im_4_6 0 s4 x10_im_a6 0 -2235391407
Gd4_7 0 s4 p7 0 0.003211058698
Fd4_7 0 s4 V7 0.1605529349
Gr1_4_7 0 s4 x1_a7 0 -5.749471285e+10
Gr2_re_4_7 0 s4 x2_re_a7 0 4.478564201e+10
Gr2_im_4_7 0 s4 x2_im_a7 0 -9.599536155e+10
Gr3_re_4_7 0 s4 x3_re_a7 0 -1.42398349e+11
Gr3_im_4_7 0 s4 x3_im_a7 0 -1.413350681e+11
Gr4_re_4_7 0 s4 x4_re_a7 0 1734587989
Gr4_im_4_7 0 s4 x4_im_a7 0 -1000852579
Gr5_re_4_7 0 s4 x5_re_a7 0 -1059100801
Gr5_im_4_7 0 s4 x5_im_a7 0 -6059290186
Gr6_re_4_7 0 s4 x6_re_a7 0 2.007882338e+10
Gr6_im_4_7 0 s4 x6_im_a7 0 2.751131263e+10
Gr7_re_4_7 0 s4 x7_re_a7 0 -9792019981
Gr7_im_4_7 0 s4 x7_im_a7 0 -3.174669083e+10
Gr8_re_4_7 0 s4 x8_re_a7 0 -320370813.4
Gr8_im_4_7 0 s4 x8_im_a7 0 -902570337.4
Gr9_re_4_7 0 s4 x9_re_a7 0 764748616.3
Gr9_im_4_7 0 s4 x9_im_a7 0 -188018269.6
Gr10_re_4_7 0 s4 x10_re_a7 0 715681749.9
Gr10_im_4_7 0 s4 x10_im_a7 0 -950309050
Cx1_a4 x1_a4 0 0.002631481677
Gx1_a4 0 x1_a4 p4 0 0.0001860738539
Fx1_a4 0 x1_a4 V4 0.009303692693
Rp1_a4 0 x1_a4 1e-09
Cx2_re_a4 x2_re_a4 0 0.002139679567
Gx2_re_a4 0 x2_re_a4 p4 0 0.0003025963863
Fx2_re_a4 0 x2_re_a4 V4 0.01512981932
Rp2_re_re_a4 0 x2_re_a4 1e-09
Gp2_re_im_a4 0 x2_re_a4 x2_im_a4 0 3229635754
Cx2_im_a4 x2_im_a4 0 0.002139679567
Gp2_im_re_a4 0 x2_im_a4 x2_re_a4 0 -3229635754
Rp2_im_im_a4 0 x2_im_a4 1e-09
Cx3_re_a4 x3_re_a4 0 0.002091274299
Gx3_re_a4 0 x3_re_a4 p4 0 0.0002957508476
Fx3_re_a4 0 x3_re_a4 V4 0.01478754238
Rp3_re_re_a4 0 x3_re_a4 1e-09
Gp3_re_im_a4 0 x3_re_a4 x3_im_a4 0 1009553277
Cx3_im_a4 x3_im_a4 0 0.002091274299
Gp3_im_re_a4 0 x3_im_a4 x3_re_a4 0 -1009553277
Rp3_im_im_a4 0 x3_im_a4 1e-09
Cx4_re_a4 x4_re_a4 0 0.01454723191
Gx4_re_a4 0 x4_re_a4 p4 0 0.002057289267
Fx4_re_a4 0 x4_re_a4 V4 0.1028644633
Rp4_re_re_a4 0 x4_re_a4 1e-09
Gp4_re_im_a4 0 x4_re_a4 x4_im_a4 0 1.951471624e+10
Cx4_im_a4 x4_im_a4 0 0.01454723191
Gp4_im_re_a4 0 x4_im_a4 x4_re_a4 0 -1.951471624e+10
Rp4_im_im_a4 0 x4_im_a4 1e-09
Cx5_re_a4 x5_re_a4 0 0.01007230363
Gx5_re_a4 0 x5_re_a4 p4 0 0.00142443884
Fx5_re_a4 0 x5_re_a4 V4 0.07122194198
Rp5_re_re_a4 0 x5_re_a4 1e-09
Gp5_re_im_a4 0 x5_re_a4 x5_im_a4 0 1.183679285e+10
Cx5_im_a4 x5_im_a4 0 0.01007230363
Gp5_im_re_a4 0 x5_im_a4 x5_re_a4 0 -1.183679285e+10
Rp5_im_im_a4 0 x5_im_a4 1e-09
Cx6_re_a4 x6_re_a4 0 0.004969238773
Gx6_re_a4 0 x6_re_a4 p4 0 0.0007027564868
Fx6_re_a4 0 x6_re_a4 V4 0.03513782434
Rp6_re_re_a4 0 x6_re_a4 1e-09
Gp6_re_im_a4 0 x6_re_a4 x6_im_a4 0 5205754834
Cx6_im_a4 x6_im_a4 0 0.004969238773
Gp6_im_re_a4 0 x6_im_a4 x6_re_a4 0 -5205754834
Rp6_im_im_a4 0 x6_im_a4 1e-09
Cx7_re_a4 x7_re_a4 0 0.007093124953
Gx7_re_a4 0 x7_re_a4 p4 0 0.001003119351
Fx7_re_a4 0 x7_re_a4 V4 0.05015596754
Rp7_re_re_a4 0 x7_re_a4 1e-09
Gp7_re_im_a4 0 x7_re_a4 x7_im_a4 0 6261898191
Cx7_im_a4 x7_im_a4 0 0.007093124953
Gp7_im_re_a4 0 x7_im_a4 x7_re_a4 0 -6261898191
Rp7_im_im_a4 0 x7_im_a4 1e-09
Cx8_re_a4 x8_re_a4 0 0.02175510083
Gx8_re_a4 0 x8_re_a4 p4 0 0.003076635864
Fx8_re_a4 0 x8_re_a4 V4 0.1538317932
Rp8_re_re_a4 0 x8_re_a4 1e-09
Gp8_re_im_a4 0 x8_re_a4 x8_im_a4 0 2.327097802e+10
Cx8_im_a4 x8_im_a4 0 0.02175510083
Gp8_im_re_a4 0 x8_im_a4 x8_re_a4 0 -2.327097802e+10
Rp8_im_im_a4 0 x8_im_a4 1e-09
Cx9_re_a4 x9_re_a4 0 0.02772087825
Gx9_re_a4 0 x9_re_a4 p4 0 0.003920324198
Fx9_re_a4 0 x9_re_a4 V4 0.1960162099
Rp9_re_re_a4 0 x9_re_a4 1e-09
Gp9_re_im_a4 0 x9_re_a4 x9_im_a4 0 2.583815977e+10
Cx9_im_a4 x9_im_a4 0 0.02772087825
Gp9_im_re_a4 0 x9_im_a4 x9_re_a4 0 -2.583815977e+10
Rp9_im_im_a4 0 x9_im_a4 1e-09
Cx10_re_a4 x10_re_a4 0 0.02248079784
Gx10_re_a4 0 x10_re_a4 p4 0 0.00317926492
Fx10_re_a4 0 x10_re_a4 V4 0.158963246
Rp10_re_re_a4 0 x10_re_a4 1e-09
Gp10_re_im_a4 0 x10_re_a4 x10_im_a4 0 2.233186075e+10
Cx10_im_a4 x10_im_a4 0 0.02248079784
Gp10_im_re_a4 0 x10_im_a4 x10_re_a4 0 -2.233186075e+10
Rp10_im_im_a4 0 x10_im_a4 1e-09
V5 p5 s5 0
R5 s5 0 50
Gd5_1 0 s5 p1 0 -0.0002954509178
Fd5_1 0 s5 V1 -0.01477254589
Gr1_5_1 0 s5 x1_a1 0 928858082.1
Gr2_re_5_1 0 s5 x2_re_a1 0 -4937586570
Gr2_im_5_1 0 s5 x2_im_a1 0 6875797187
Gr3_re_5_1 0 s5 x3_re_a1 0 7013546248
Gr3_im_5_1 0 s5 x3_im_a1 0 -651315050.1
Gr4_re_5_1 0 s5 x4_re_a1 0 11457305.56
Gr4_im_5_1 0 s5 x4_im_a1 0 51531723.65
Gr5_re_5_1 0 s5 x5_re_a1 0 -1238196252
Gr5_im_5_1 0 s5 x5_im_a1 0 -2411543836
Gr6_re_5_1 0 s5 x6_re_a1 0 1.179152332e+10
Gr6_im_5_1 0 s5 x6_im_a1 0 1.226625664e+10
Gr7_re_5_1 0 s5 x7_re_a1 0 -1976721795
Gr7_im_5_1 0 s5 x7_im_a1 0 -3341431027
Gr8_re_5_1 0 s5 x8_re_a1 0 -3325149554
Gr8_im_5_1 0 s5 x8_im_a1 0 -2200381560
Gr9_re_5_1 0 s5 x9_re_a1 0 218788505.5
Gr9_im_5_1 0 s5 x9_im_a1 0 -1851072263
Gr10_re_5_1 0 s5 x10_re_a1 0 744123056
Gr10_im_5_1 0 s5 x10_im_a1 0 2399899446
Gd5_2 0 s5 p2 0 -0.0003132020177
Fd5_2 0 s5 V2 -0.01566010089
Gr1_5_2 0 s5 x1_a2 0 -7.093938185e+10
Gr2_re_5_2 0 s5 x2_re_a2 0 -9913224697
Gr2_im_5_2 0 s5 x2_im_a2 0 1.004639139e+11
Gr3_re_5_2 0 s5 x3_re_a2 0 -6.906249187e+10
Gr3_im_5_2 0 s5 x3_im_a2 0 -1.988507169e+11
Gr4_re_5_2 0 s5 x4_re_a2 0 -55772583.01
Gr4_im_5_2 0 s5 x4_im_a2 0 1452367952
Gr5_re_5_2 0 s5 x5_re_a2 0 1601409469
Gr5_im_5_2 0 s5 x5_im_a2 0 3169204003
Gr6_re_5_2 0 s5 x6_re_a2 0 1.102939518e+11
Gr6_im_5_2 0 s5 x6_im_a2 0 1.322230057e+10
Gr7_re_5_2 0 s5 x7_re_a2 0 1.474123702e+10
Gr7_im_5_2 0 s5 x7_im_a2 0 -2.929430994e+10
Gr8_re_5_2 0 s5 x8_re_a2 0 -575956396.9
Gr8_im_5_2 0 s5 x8_im_a2 0 -783626730.2
Gr9_re_5_2 0 s5 x9_re_a2 0 565380526.4
Gr9_im_5_2 0 s5 x9_im_a2 0 -237744823.7
Gr10_re_5_2 0 s5 x10_re_a2 0 677806445.3
Gr10_im_5_2 0 s5 x10_im_a2 0 -1323082282
Gd5_3 0 s5 p3 0 -0.007149869515
Fd5_3 0 s5 V3 -0.3574934757
Gr1_5_3 0 s5 x1_a3 0 2.503384884e+11
Gr2_re_5_3 0 s5 x2_re_a3 0 5588310651
Gr2_im_5_3 0 s5 x2_im_a3 0 1.748417736e+11
Gr3_re_5_3 0 s5 x3_re_a3 0 1.857748866e+10
Gr3_im_5_3 0 s5 x3_im_a3 0 2.091604241e+11
Gr4_re_5_3 0 s5 x4_re_a3 0 -3614630.195
Gr4_im_5_3 0 s5 x4_im_a3 0 -3080912456
Gr5_re_5_3 0 s5 x5_re_a3 0 -8500813468
Gr5_im_5_3 0 s5 x5_im_a3 0 1.634807445e+10
Gr6_re_5_3 0 s5 x6_re_a3 0 1.092387688e+11
Gr6_im_5_3 0 s5 x6_im_a3 0 -6.598674705e+10
Gr7_re_5_3 0 s5 x7_re_a3 0 -4.334837746e+10
Gr7_im_5_3 0 s5 x7_im_a3 0 4453865048
Gr8_re_5_3 0 s5 x8_re_a3 0 -2908680516
Gr8_im_5_3 0 s5 x8_im_a3 0 1155576252
Gr9_re_5_3 0 s5 x9_re_a3 0 -1391425967
Gr9_im_5_3 0 s5 x9_im_a3 0 -2410533328
Gr10_re_5_3 0 s5 x10_re_a3 0 -3879366949
Gr10_im_5_3 0 s5 x10_im_a3 0 -2680213522
Gd5_4 0 s5 p4 0 0.00304860593
Fd5_4 0 s5 V4 0.1524302965
Gr1_5_4 0 s5 x1_a4 0 1.842970854e+11
Gr2_re_5_4 0 s5 x2_re_a4 0 -2.078206713e+10
Gr2_im_5_4 0 s5 x2_im_a4 0 -1.064697694e+11
Gr3_re_5_4 0 s5 x3_re_a4 0 -7.022731537e+10
Gr3_im_5_4 0 s5 x3_im_a4 0 1.790315172e+11
Gr4_re_5_4 0 s5 x4_re_a4 0 -4084131072
Gr4_im_5_4 0 s5 x4_im_a4 0 5153231831
Gr5_re_5_4 0 s5 x5_re_a4 0 1.378648454e+10
Gr5_im_5_4 0 s5 x5_im_a4 0 2943397894
Gr6_re_5_4 0 s5 x6_re_a4 0 -1.042198863e+11
Gr6_im_5_4 0 s5 x6_im_a4 0 -5.050492772e+10
Gr7_re_5_4 0 s5 x7_re_a4 0 1.572755061e+10
Gr7_im_5_4 0 s5 x7_im_a4 0 4.298004517e+10
Gr8_re_5_4 0 s5 x8_re_a4 0 1664694972
Gr8_im_5_4 0 s5 x8_im_a4 0 28068512.17
Gr9_re_5_4 0 s5 x9_re_a4 0 -1157119650
Gr9_im_5_4 0 s5 x9_im_a4 0 297630857.5
Gr10_re_5_4 0 s5 x10_re_a4 0 -344282868.1
Gr10_im_5_4 0 s5 x10_im_a4 0 1741806719
Gd5_5 0 s5 p5 0 -0.005754558296
Fd5_5 0 s5 V5 -0.2877279148
Gr1_5_5 0 s5 x1_a5 0 -1.274678521e+11
Gr2_re_5_5 0 s5 x2_re_a5 0 3.445403943e+10
Gr2_im_5_5 0 s5 x2_im_a5 0 -7234775869
Gr3_re_5_5 0 s5 x3_re_a5 0 3.533459506e+10
Gr3_im_5_5 0 s5 x3_im_a5 0 -4.261010698e+10
Gr4_re_5_5 0 s5 x4_re_a5 0 959349586.2
Gr4_im_5_5 0 s5 x4_im_a5 0 -5497451967
Gr5_re_5_5 0 s5 x5_re_a5 0 7915801225
Gr5_im_5_5 0 s5 x5_im_a5 0 7005862144
Gr6_re_5_5 0 s5 x6_re_a5 0 -2.637150198e+10
Gr6_im_5_5 0 s5 x6_im_a5 0 -9.165744719e+10
Gr7_re_5_5 0 s5 x7_re_a5 0 -1.303547112e+10
Gr7_im_5_5 0 s5 x7_im_a5 0 5.001169604e+10
Gr8_re_5_5 0 s5 x8_re_a5 0 1780737163
Gr8_im_5_5 0 s5 x8_im_a5 0 4016298069
Gr9_re_5_5 0 s5 x9_re_a5 0 -1372712324
Gr9_im_5_5 0 s5 x9_im_a5 0 1071081894
Gr10_re_5_5 0 s5 x10_re_a5 0 -2478760869
Gr10_im_5_5 0 s5 x10_im_a5 0 3884282853
Gd5_6 0 s5 p6 0 0.004109416267
Fd5_6 0 s5 V6 0.2054708134
Gr1_5_6 0 s5 x1_a6 0 -9.647794937e+10
Gr2_re_5_6 0 s5 x2_re_a6 0 -5.268991797e+10
Gr2_im_5_6 0 s5 x2_im_a6 0 -1.468023084e+11
Gr3_re_5_6 0 s5 x3_re_a6 0 6.484312407e+10
Gr3_im_5_6 0 s5 x3_im_a6 0 -5.661139473e+10
Gr4_re_5_6 0 s5 x4_re_a6 0 -3550845011
Gr4_im_5_6 0 s5 x4_im_a6 0 2708549147
Gr5_re_5_6 0 s5 x5_re_a6 0 2.728833106e+10
Gr5_im_5_6 0 s5 x5_im_a6 0 -5379358374
Gr6_re_5_6 0 s5 x6_re_a6 0 -1.553913259e+11
Gr6_im_5_6 0 s5 x6_im_a6 0 -3.076921865e+10
Gr7_re_5_6 0 s5 x7_re_a6 0 2.877719065e+10
Gr7_im_5_6 0 s5 x7_im_a6 0 6.298209837e+10
Gr8_re_5_6 0 s5 x8_re_a6 0 5314908055
Gr8_im_5_6 0 s5 x8_im_a6 0 2068012316
Gr9_re_5_6 0 s5 x9_re_a6 0 -1316414477
Gr9_im_5_6 0 s5 x9_im_a6 0 2610698534
Gr10_re_5_6 0 s5 x10_re_a6 0 514738886.4
Gr10_im_5_6 0 s5 x10_im_a6 0 6741681105
Gd5_7 0 s5 p7 0 0.004789187311
Fd5_7 0 s5 V7 0.2394593655
Gr1_5_7 0 s5 x1_a7 0 -1.816471619e+11
Gr2_re_5_7 0 s5 x2_re_a7 0 4.434983993e+10
Gr2_im_5_7 0 s5 x2_im_a7 0 -1.401954245e+11
Gr3_re_5_7 0 s5 x3_re_a7 0 -1.216152218e+11
Gr3_im_5_7 0 s5 x3_im_a7 0 -2.573063995e+11
Gr4_re_5_7 0 s5 x4_re_a7 0 -438698498
Gr4_im_5_7 0 s5 x4_im_a7 0 1628737919
Gr5_re_5_7 0 s5 x5_re_a7 0 4654730572
Gr5_im_5_7 0 s5 x5_im_a7 0 -3132736776
Gr6_re_5_7 0 s5 x6_re_a7 0 -2.361681042e+10
Gr6_im_5_7 0 s5 x6_im_a7 0 2.795588716e+10
Gr7_re_5_7 0 s5 x7_re_a7 0 1.905562479e+10
Gr7_im_5_7 0 s5 x7_im_a7 0 -1.003369553e+10
Gr8_re_5_7 0 s5 x8_re_a7 0 1459385005
Gr8_im_5_7 0 s5 x8_im_a7 0 -106952519.5
Gr9_re_5_7 0 s5 x9_re_a7 0 341497938.4
Gr9_im_5_7 0 s5 x9_im_a7 0 1104356676
Gr10_re_5_7 0 s5 x10_re_a7 0 1277222078
Gr10_im_5_7 0 s5 x10_im_a7 0 1481324792
Cx1_a5 x1_a5 0 0.002631481677
Gx1_a5 0 x1_a5 p5 0 0.0001860738539
Fx1_a5 0 x1_a5 V5 0.009303692693
Rp1_a5 0 x1_a5 1e-09
Cx2_re_a5 x2_re_a5 0 0.002139679567
Gx2_re_a5 0 x2_re_a5 p5 0 0.0003025963863
Fx2_re_a5 0 x2_re_a5 V5 0.01512981932
Rp2_re_re_a5 0 x2_re_a5 1e-09
Gp2_re_im_a5 0 x2_re_a5 x2_im_a5 0 3229635754
Cx2_im_a5 x2_im_a5 0 0.002139679567
Gp2_im_re_a5 0 x2_im_a5 x2_re_a5 0 -3229635754
Rp2_im_im_a5 0 x2_im_a5 1e-09
Cx3_re_a5 x3_re_a5 0 0.002091274299
Gx3_re_a5 0 x3_re_a5 p5 0 0.0002957508476
Fx3_re_a5 0 x3_re_a5 V5 0.01478754238
Rp3_re_re_a5 0 x3_re_a5 1e-09
Gp3_re_im_a5 0 x3_re_a5 x3_im_a5 0 1009553277
Cx3_im_a5 x3_im_a5 0 0.002091274299
Gp3_im_re_a5 0 x3_im_a5 x3_re_a5 0 -1009553277
Rp3_im_im_a5 0 x3_im_a5 1e-09
Cx4_re_a5 x4_re_a5 0 0.01454723191
Gx4_re_a5 0 x4_re_a5 p5 0 0.002057289267
Fx4_re_a5 0 x4_re_a5 V5 0.1028644633
Rp4_re_re_a5 0 x4_re_a5 1e-09
Gp4_re_im_a5 0 x4_re_a5 x4_im_a5 0 1.951471624e+10
Cx4_im_a5 x4_im_a5 0 0.01454723191
Gp4_im_re_a5 0 x4_im_a5 x4_re_a5 0 -1.951471624e+10
Rp4_im_im_a5 0 x4_im_a5 1e-09
Cx5_re_a5 x5_re_a5 0 0.01007230363
Gx5_re_a5 0 x5_re_a5 p5 0 0.00142443884
Fx5_re_a5 0 x5_re_a5 V5 0.07122194198
Rp5_re_re_a5 0 x5_re_a5 1e-09
Gp5_re_im_a5 0 x5_re_a5 x5_im_a5 0 1.183679285e+10
Cx5_im_a5 x5_im_a5 0 0.01007230363
Gp5_im_re_a5 0 x5_im_a5 x5_re_a5 0 -1.183679285e+10
Rp5_im_im_a5 0 x5_im_a5 1e-09
Cx6_re_a5 x6_re_a5 0 0.004969238773
Gx6_re_a5 0 x6_re_a5 p5 0 0.0007027564868
Fx6_re_a5 0 x6_re_a5 V5 0.03513782434
Rp6_re_re_a5 0 x6_re_a5 1e-09
Gp6_re_im_a5 0 x6_re_a5 x6_im_a5 0 5205754834
Cx6_im_a5 x6_im_a5 0 0.004969238773
Gp6_im_re_a5 0 x6_im_a5 x6_re_a5 0 -5205754834
Rp6_im_im_a5 0 x6_im_a5 1e-09
Cx7_re_a5 x7_re_a5 0 0.007093124953
Gx7_re_a5 0 x7_re_a5 p5 0 0.001003119351
Fx7_re_a5 0 x7_re_a5 V5 0.05015596754
Rp7_re_re_a5 0 x7_re_a5 1e-09
Gp7_re_im_a5 0 x7_re_a5 x7_im_a5 0 6261898191
Cx7_im_a5 x7_im_a5 0 0.007093124953
Gp7_im_re_a5 0 x7_im_a5 x7_re_a5 0 -6261898191
Rp7_im_im_a5 0 x7_im_a5 1e-09
Cx8_re_a5 x8_re_a5 0 0.02175510083
Gx8_re_a5 0 x8_re_a5 p5 0 0.003076635864
Fx8_re_a5 0 x8_re_a5 V5 0.1538317932
Rp8_re_re_a5 0 x8_re_a5 1e-09
Gp8_re_im_a5 0 x8_re_a5 x8_im_a5 0 2.327097802e+10
Cx8_im_a5 x8_im_a5 0 0.02175510083
Gp8_im_re_a5 0 x8_im_a5 x8_re_a5 0 -2.327097802e+10
Rp8_im_im_a5 0 x8_im_a5 1e-09
Cx9_re_a5 x9_re_a5 0 0.02772087825
Gx9_re_a5 0 x9_re_a5 p5 0 0.003920324198
Fx9_re_a5 0 x9_re_a5 V5 0.1960162099
Rp9_re_re_a5 0 x9_re_a5 1e-09
Gp9_re_im_a5 0 x9_re_a5 x9_im_a5 0 2.583815977e+10
Cx9_im_a5 x9_im_a5 0 0.02772087825
Gp9_im_re_a5 0 x9_im_a5 x9_re_a5 0 -2.583815977e+10
Rp9_im_im_a5 0 x9_im_a5 1e-09
Cx10_re_a5 x10_re_a5 0 0.02248079784
Gx10_re_a5 0 x10_re_a5 p5 0 0.00317926492
Fx10_re_a5 0 x10_re_a5 V5 0.158963246
Rp10_re_re_a5 0 x10_re_a5 1e-09
Gp10_re_im_a5 0 x10_re_a5 x10_im_a5 0 2.233186075e+10
Cx10_im_a5 x10_im_a5 0 0.02248079784
Gp10_im_re_a5 0 x10_im_a5 x10_re_a5 0 -2.233186075e+10
Rp10_im_im_a5 0 x10_im_a5 1e-09
V6 p6 s6 0
R6 s6 0 50
Gd6_1 0 s6 p1 0 -3.798195827e-06
Fd6_1 0 s6 V1 -0.0001899097914
Gr1_6_1 0 s6 x1_a1 0 -9976179832
Gr2_re_6_1 0 s6 x2_re_a1 0 5369840233
Gr2_im_6_1 0 s6 x2_im_a1 0 923525380.8
Gr3_re_6_1 0 s6 x3_re_a1 0 -6183381499
Gr3_im_6_1 0 s6 x3_im_a1 0 -9411974153
Gr4_re_6_1 0 s6 x4_re_a1 0 -130336083.5
Gr4_im_6_1 0 s6 x4_im_a1 0 -38616840.63
Gr5_re_6_1 0 s6 x5_re_a1 0 -3568109753
Gr5_im_6_1 0 s6 x5_im_a1 0 1382413730
Gr6_re_6_1 0 s6 x6_re_a1 0 1.312295242e+10
Gr6_im_6_1 0 s6 x6_im_a1 0 -1.44198e+10
Gr7_re_6_1 0 s6 x7_re_a1 0 -4727272913
Gr7_im_6_1 0 s6 x7_im_a1 0 3238759296
Gr8_re_6_1 0 s6 x8_re_a1 0 -2674147096
Gr8_im_6_1 0 s6 x8_im_a1 0 4138363192
Gr9_re_6_1 0 s6 x9_re_a1 0 -2203738359
Gr9_im_6_1 0 s6 x9_im_a1 0 -680519080.5
Gr10_re_6_1 0 s6 x10_re_a1 0 3144048412
Gr10_im_6_1 0 s6 x10_im_a1 0 -533136713.9
Gd6_2 0 s6 p2 0 0.003265681578
Fd6_2 0 s6 V2 0.1632840789
Gr1_6_2 0 s6 x1_a2 0 -6.712289382e+10
Gr2_re_6_2 0 s6 x2_re_a2 0 4.86257948e+10
Gr2_im_6_2 0 s6 x2_im_a2 0 -9.546178556e+10
Gr3_re_6_2 0 s6 x3_re_a2 0 -1.451330149e+11
Gr3_im_6_2 0 s6 x3_im_a2 0 -1.520132409e+11
Gr4_re_6_2 0 s6 x4_re_a2 0 1649529386
Gr4_im_6_2 0 s6 x4_im_a2 0 -1506428120
Gr5_re_6_2 0 s6 x5_re_a2 0 -1105878299
Gr5_im_6_2 0 s6 x5_im_a2 0 -5708740880
Gr6_re_6_2 0 s6 x6_re_a2 0 2.1540902e+10
Gr6_im_6_2 0 s6 x6_im_a2 0 2.606048053e+10
Gr7_re_6_2 0 s6 x7_re_a2 0 -9776177864
Gr7_im_6_2 0 s6 x7_im_a2 0 -3.24841559e+10
Gr8_re_6_2 0 s6 x8_re_a2 0 -302735091.9
Gr8_im_6_2 0 s6 x8_im_a2 0 -844446673.2
Gr9_re_6_2 0 s6 x9_re_a2 0 807004273.8
Gr9_im_6_2 0 s6 x9_im_a2 0 -167471043
Gr10_re_6_2 0 s6 x10_re_a2 0 727129250.6
Gr10_im_6_2 0 s6 x10_im_a2 0 -934337473.5
Gd6_3 0 s6 p3 0 0.002908189119
Fd6_3 0 s6 V3 0.1454094559
Gr1_6_3 0 s6 x1_a3 0 1.884440655e+11
Gr2_re_6_3 0 s6 x2_re_a3 0 -2.07376733e+10
Gr2_im_6_3 0 s6 x2_im_a3 0 -1.043000243e+11
Gr3_re_6_3 0 s6 x3_re_a3 0 -6.895718342e+10
Gr3_im_6_3 0 s6 x3_im_a3 0 1.827797252e+11
Gr4_re_6_3 0 s6 x4_re_a3 0 -4294062344
Gr4_im_6_3 0 s6 x4_im_a3 0 5038415336
Gr5_re_6_3 0 s6 x5_re_a3 0 1.347298872e+10
Gr5_im_6_3 0 s6 x5_im_a3 0 3023307423
Gr6_re_6_3 0 s6 x6_re_a3 0 -1.027906239e+11
Gr6_im_6_3 0 s6 x6_im_a3 0 -4.989053277e+10
Gr7_re_6_3 0 s6 x7_re_a3 0 1.525394698e+10
Gr7_im_6_3 0 s6 x7_im_a3 0 4.282563373e+10
Gr8_re_6_3 0 s6 x8_re_a3 0 1604594315
Gr8_im_6_3 0 s6 x8_im_a3 0 3485537.86
Gr9_re_6_3 0 s6 x9_re_a3 0 -1175107936
Gr9_im_6_3 0 s6 x9_im_a3 0 246296592.2
Gr10_re_6_3 0 s6 x10_re_a3 0 -374914122.5
Gr10_im_6_3 0 s6 x10_im_a3 0 1655723216
Gd6_4 0 s6 p4 0 -0.004226562547
Fd6_4 0 s6 V4 -0.2113281273
Gr1_6_4 0 s6 x1_a4 0 2.556921973e+11
Gr2_re_6_4 0 s6 x2_re_a4 0 -1.037008055e+11
Gr2_im_6_4 0 s6 x2_im_a4 0 5.942874271e+10
Gr3_re_6_4 0 s6 x3_re_a4 0 9.677427335e+10
Gr3_im_6_4 0 s6 x3_im_a4 0 1.97597291e+11
Gr4_re_6_4 0 s6 x4_re_a4 0 7160951851
Gr4_im_6_4 0 s6 x4_im_a4 0 -776966395.3
Gr5_re_6_4 0 s6 x5_re_a4 0 -5262409853
Gr5_im_6_4 0 s6 x5_im_a4 0 -2.358788893e+10
Gr6_re_6_4 0 s6 x6_re_a4 0 -4.066638358e+10
Gr6_im_6_4 0 s6 x6_im_a4 0 1.730059456e+11
Gr7_re_6_4 0 s6 x7_re_a4 0 5.807362431e+10
Gr7_im_6_4 0 s6 x7_im_a4 0 -3.082750106e+10
Gr8_re_6_4 0 s6 x8_re_a4 0 -1290673156
Gr8_im_6_4 0 s6 x8_im_a4 0 -4488042837
Gr9_re_6_4 0 s6 x9_re_a4 0 547510251.2
Gr9_im_6_4 0 s6 x9_im_a4 0 -86036492.45
Gr10_re_6_4 0 s6 x10_re_a4 0 2717466546
Gr10_im_6_4 0 s6 x10_im_a4 0 -2235391407
Gd6_5 0 s6 p5 0 0.004109416267
Fd6_5 0 s6 V5 0.2054708134
Gr1_6_5 0 s6 x1_a5 0 -9.647794937e+10
Gr2_re_6_5 0 s6 x2_re_a5 0 -5.268991797e+10
Gr2_im_6_5 0 s6 x2_im_a5 0 -1.468023084e+11
Gr3_re_6_5 0 s6 x3_re_a5 0 6.484312407e+10
Gr3_im_6_5 0 s6 x3_im_a5 0 -5.661139473e+10
Gr4_re_6_5 0 s6 x4_re_a5 0 -3550845011
Gr4_im_6_5 0 s6 x4_im_a5 0 2708549148
Gr5_re_6_5 0 s6 x5_re_a5 0 2.728833106e+10
Gr5_im_6_5 0 s6 x5_im_a5 0 -5379358374
Gr6_re_6_5 0 s6 x6_re_a5 0 -1.553913259e+11
Gr6_im_6_5 0 s6 x6_im_a5 0 -3.076921864e+10
Gr7_re_6_5 0 s6 x7_re_a5 0 2.877719065e+10
Gr7_im_6_5 0 s6 x7_im_a5 0 6.298209837e+10
Gr8_re_6_5 0 s6 x8_re_a5 0 5314908055
Gr8_im_6_5 0 s6 x8_im_a5 0 2068012316
Gr9_re_6_5 0 s6 x9_re_a5 0 -1316414477
Gr9_im_6_5 0 s6 x9_im_a5 0 2610698534
Gr10_re_6_5 0 s6 x10_re_a5 0 514738886.5
Gr10_im_6_5 0 s6 x10_im_a5 0 6741681105
Gd6_6 0 s6 p6 0 -0.005969500562
Fd6_6 0 s6 V6 -0.2984750281
Gr1_6_6 0 s6 x1_a6 0 -5.345413271e+10
Gr2_re_6_6 0 s6 x2_re_a6 0 -7.732033583e+10
Gr2_im_6_6 0 s6 x2_im_a6 0 -3393637237
Gr3_re_6_6 0 s6 x3_re_a6 0 9.9217724e+10
Gr3_im_6_6 0 s6 x3_im_a6 0 -2.676114758e+10
Gr4_re_6_6 0 s6 x4_re_a6 0 8217645715
Gr4_im_6_6 0 s6 x4_im_a6 0 -3518394187
Gr5_re_6_6 0 s6 x5_re_a6 0 4636240354
Gr5_im_6_6 0 s6 x5_im_a6 0 -3.231066957e+10
Gr6_re_6_6 0 s6 x6_re_a6 0 -9.705141302e+10
Gr6_im_6_6 0 s6 x6_im_a6 0 1.1980681e+11
Gr7_re_6_6 0 s6 x7_re_a6 0 8.699795658e+10
Gr7_im_6_6 0 s6 x7_im_a6 0 1.036625857e+10
Gr8_re_6_6 0 s6 x8_re_a6 0 2331555872
Gr8_im_6_6 0 s6 x8_im_a6 0 -3077168484
Gr9_re_6_6 0 s6 x9_re_a6 0 1075404247
Gr9_im_6_6 0 s6 x9_im_a6 0 2826606853
Gr10_re_6_6 0 s6 x10_re_a6 0 5163041800
Gr10_im_6_6 0 s6 x10_im_a6 0 2439968138
Gd6_7 0 s6 p7 0 -0.0001600670621
Fd6_7 0 s6 V7 -0.008003353107
Gr1_6_7 0 s6 x1_a7 0 -6.053883829e+10
Gr2_re_6_7 0 s6 x2_re_a7 0 3.360095943e+10
Gr2_im_6_7 0 s6 x2_im_a7 0 9.381024206e+10
Gr3_re_6_7 0 s6 x3_re_a7 0 -3.993154644e+10
Gr3_im_6_7 0 s6 x3_im_a7 0 -1.579221026e+11
Gr4_re_6_7 0 s6 x4_re_a7 0 3035997744
Gr4_im_6_7 0 s6 x4_im_a7 0 -1639430076
Gr5_re_6_7 0 s6 x5_re_a7 0 -819081043.8
Gr5_im_6_7 0 s6 x5_im_a7 0 1127092807
Gr6_re_6_7 0 s6 x6_re_a7 0 6.336330454e+10
Gr6_im_6_7 0 s6 x6_im_a7 0 1.42831819e+10
Gr7_re_6_7 0 s6 x7_re_a7 0 -5129809587
Gr7_im_6_7 0 s6 x7_im_a7 0 -3.797751558e+10
Gr8_re_6_7 0 s6 x8_re_a7 0 -1681706748
Gr8_im_6_7 0 s6 x8_im_a7 0 -929637277.9
Gr9_re_6_7 0 s6 x9_re_a7 0 1065730749
Gr9_im_6_7 0 s6 x9_im_a7 0 -576584873.4
Gr10_re_6_7 0 s6 x10_re_a7 0 627429065.7
Gr10_im_6_7 0 s6 x10_im_a7 0 -2344019283
Cx1_a6 x1_a6 0 0.002631481677
Gx1_a6 0 x1_a6 p6 0 0.0001860738539
Fx1_a6 0 x1_a6 V6 0.009303692693
Rp1_a6 0 x1_a6 1e-09
Cx2_re_a6 x2_re_a6 0 0.002139679567
Gx2_re_a6 0 x2_re_a6 p6 0 0.0003025963863
Fx2_re_a6 0 x2_re_a6 V6 0.01512981932
Rp2_re_re_a6 0 x2_re_a6 1e-09
Gp2_re_im_a6 0 x2_re_a6 x2_im_a6 0 3229635754
Cx2_im_a6 x2_im_a6 0 0.002139679567
Gp2_im_re_a6 0 x2_im_a6 x2_re_a6 0 -3229635754
Rp2_im_im_a6 0 x2_im_a6 1e-09
Cx3_re_a6 x3_re_a6 0 0.002091274299
Gx3_re_a6 0 x3_re_a6 p6 0 0.0002957508476
Fx3_re_a6 0 x3_re_a6 V6 0.01478754238
Rp3_re_re_a6 0 x3_re_a6 1e-09
Gp3_re_im_a6 0 x3_re_a6 x3_im_a6 0 1009553277
Cx3_im_a6 x3_im_a6 0 0.002091274299
Gp3_im_re_a6 0 x3_im_a6 x3_re_a6 0 -1009553277
Rp3_im_im_a6 0 x3_im_a6 1e-09
Cx4_re_a6 x4_re_a6 0 0.01454723191
Gx4_re_a6 0 x4_re_a6 p6 0 0.002057289267
Fx4_re_a6 0 x4_re_a6 V6 0.1028644633
Rp4_re_re_a6 0 x4_re_a6 1e-09
Gp4_re_im_a6 0 x4_re_a6 x4_im_a6 0 1.951471624e+10
Cx4_im_a6 x4_im_a6 0 0.01454723191
Gp4_im_re_a6 0 x4_im_a6 x4_re_a6 0 -1.951471624e+10
Rp4_im_im_a6 0 x4_im_a6 1e-09
Cx5_re_a6 x5_re_a6 0 0.01007230363
Gx5_re_a6 0 x5_re_a6 p6 0 0.00142443884
Fx5_re_a6 0 x5_re_a6 V6 0.07122194198
Rp5_re_re_a6 0 x5_re_a6 1e-09
Gp5_re_im_a6 0 x5_re_a6 x5_im_a6 0 1.183679285e+10
Cx5_im_a6 x5_im_a6 0 0.01007230363
Gp5_im_re_a6 0 x5_im_a6 x5_re_a6 0 -1.183679285e+10
Rp5_im_im_a6 0 x5_im_a6 1e-09
Cx6_re_a6 x6_re_a6 0 0.004969238773
Gx6_re_a6 0 x6_re_a6 p6 0 0.0007027564868
Fx6_re_a6 0 x6_re_a6 V6 0.03513782434
Rp6_re_re_a6 0 x6_re_a6 1e-09
Gp6_re_im_a6 0 x6_re_a6 x6_im_a6 0 5205754834
Cx6_im_a6 x6_im_a6 0 0.004969238773
Gp6_im_re_a6 0 x6_im_a6 x6_re_a6 0 -5205754834
Rp6_im_im_a6 0 x6_im_a6 1e-09
Cx7_re_a6 x7_re_a6 0 0.007093124953
Gx7_re_a6 0 x7_re_a6 p6 0 0.001003119351
Fx7_re_a6 0 x7_re_a6 V6 0.05015596754
Rp7_re_re_a6 0 x7_re_a6 1e-09
Gp7_re_im_a6 0 x7_re_a6 x7_im_a6 0 6261898191
Cx7_im_a6 x7_im_a6 0 0.007093124953
Gp7_im_re_a6 0 x7_im_a6 x7_re_a6 0 -6261898191
Rp7_im_im_a6 0 x7_im_a6 1e-09
Cx8_re_a6 x8_re_a6 0 0.02175510083
Gx8_re_a6 0 x8_re_a6 p6 0 0.003076635864
Fx8_re_a6 0 x8_re_a6 V6 0.1538317932
Rp8_re_re_a6 0 x8_re_a6 1e-09
Gp8_re_im_a6 0 x8_re_a6 x8_im_a6 0 2.327097802e+10
Cx8_im_a6 x8_im_a6 0 0.02175510083
Gp8_im_re_a6 0 x8_im_a6 x8_re_a6 0 -2.327097802e+10
Rp8_im_im_a6 0 x8_im_a6 1e-09
Cx9_re_a6 x9_re_a6 0 0.02772087825
Gx9_re_a6 0 x9_re_a6 p6 0 0.003920324198
Fx9_re_a6 0 x9_re_a6 V6 0.1960162099
Rp9_re_re_a6 0 x9_re_a6 1e-09
Gp9_re_im_a6 0 x9_re_a6 x9_im_a6 0 2.583815977e+10
Cx9_im_a6 x9_im_a6 0 0.02772087825
Gp9_im_re_a6 0 x9_im_a6 x9_re_a6 0 -2.583815977e+10
Rp9_im_im_a6 0 x9_im_a6 1e-09
Cx10_re_a6 x10_re_a6 0 0.02248079784
Gx10_re_a6 0 x10_re_a6 p6 0 0.00317926492
Fx10_re_a6 0 x10_re_a6 V6 0.158963246
Rp10_re_re_a6 0 x10_re_a6 1e-09
Gp10_re_im_a6 0 x10_re_a6 x10_im_a6 0 2.233186075e+10
Cx10_im_a6 x10_im_a6 0 0.02248079784
Gp10_im_re_a6 0 x10_im_a6 x10_re_a6 0 -2.233186075e+10
Rp10_im_im_a6 0 x10_im_a6 1e-09
V7 p7 s7 0
R7 s7 0 50
Gd7_1 0 s7 p1 0 -2.211196203e-05
Fd7_1 0 s7 V1 -0.001105598101
Gr1_7_1 0 s7 x1_a1 0 1083935503
Gr2_re_7_1 0 s7 x2_re_a1 0 -414433723.2
Gr2_im_7_1 0 s7 x2_im_a1 0 -27640814.22
Gr3_re_7_1 0 s7 x3_re_a1 0 636091844.6
Gr3_im_7_1 0 s7 x3_im_a1 0 1127137204
Gr4_re_7_1 0 s7 x4_re_a1 0 -80428061.19
Gr4_im_7_1 0 s7 x4_im_a1 0 -11958434.28
Gr5_re_7_1 0 s7 x5_re_a1 0 -724748385.7
Gr5_im_7_1 0 s7 x5_im_a1 0 233123833.6
Gr6_re_7_1 0 s7 x6_re_a1 0 524847405.4
Gr6_im_7_1 0 s7 x6_im_a1 0 -959056394.1
Gr7_re_7_1 0 s7 x7_re_a1 0 557294093.6
Gr7_im_7_1 0 s7 x7_im_a1 0 618458291.1
Gr8_re_7_1 0 s7 x8_re_a1 0 89019222.76
Gr8_im_7_1 0 s7 x8_im_a1 0 665897727.2
Gr9_re_7_1 0 s7 x9_re_a1 0 -286282749.4
Gr9_im_7_1 0 s7 x9_im_a1 0 628482473
Gr10_re_7_1 0 s7 x10_re_a1 0 -224554221.2
Gr10_im_7_1 0 s7 x10_im_a1 0 -665736142.3
Gd7_2 0 s7 p2 0 -0.002316618278
Fd7_2 0 s7 V2 -0.1158309139
Gr1_7_2 0 s7 x1_a2 0 1.770309783e+11
Gr2_re_7_2 0 s7 x2_re_a2 0 -1.002646187e+11
Gr2_im_7_2 0 s7 x2_im_a2 0 2.10763558e+10
Gr3_re_7_2 0 s7 x3_re_a2 0 1.009373731e+11
Gr3_im_7_2 0 s7 x3_im_a2 0 1.990752319e+11
Gr4_re_7_2 0 s7 x4_re_a2 0 -185137221.7
Gr4_im_7_2 0 s7 x4_im_a2 0 -1297618616
Gr5_re_7_2 0 s7 x5_re_a2 0 3055995042
Gr5_im_7_2 0 s7 x5_im_a2 0 -1227961273
Gr6_re_7_2 0 s7 x6_re_a2 0 210901262.2
Gr6_im_7_2 0 s7 x6_im_a2 0 6412350872
Gr7_re_7_2 0 s7 x7_re_a2 0 -2.665920847e+10
Gr7_im_7_2 0 s7 x7_im_a2 0 8408770781
Gr8_re_7_2 0 s7 x8_re_a2 0 -428442087.7
Gr8_im_7_2 0 s7 x8_im_a2 0 696905269.1
Gr9_re_7_2 0 s7 x9_re_a2 0 -645850171
Gr9_im_7_2 0 s7 x9_im_a2 0 -672920013.2
Gr10_re_7_2 0 s7 x10_re_a2 0 -1470378265
Gr10_im_7_2 0 s7 x10_im_a2 0 -250740435.6
Gd7_3 0 s7 p3 0 -0.0005371468308
Fd7_3 0 s7 V3 -0.02685734154
Gr1_7_3 0 s7 x1_a3 0 -6.155342672e+10
Gr2_re_7_3 0 s7 x2_re_a3 0 -1.001442867e+10
Gr2_im_7_3 0 s7 x2_im_a3 0 1.038114939e+11
Gr3_re_7_3 0 s7 x3_re_a3 0 -6.71741821e+10
Gr3_im_7_3 0 s7 x3_im_a3 0 -1.901733806e+11
Gr4_re_7_3 0 s7 x4_re_a3 0 -402530772.6
Gr4_im_7_3 0 s7 x4_im_a3 0 1275671142
Gr5_re_7_3 0 s7 x5_re_a3 0 1514209731
Gr5_im_7_3 0 s7 x5_im_a3 0 3445509828
Gr6_re_7_3 0 s7 x6_re_a3 0 1.110336944e+11
Gr6_im_7_3 0 s7 x6_im_a3 0 1.329135451e+10
Gr7_re_7_3 0 s7 x7_re_a3 0 1.421600913e+10
Gr7_im_7_3 0 s7 x7_im_a3 0 -2.90640721e+10
Gr8_re_7_3 0 s7 x8_re_a3 0 -611147542.5
Gr8_im_7_3 0 s7 x8_im_a3 0 -813285361.3
Gr9_re_7_3 0 s7 x9_re_a3 0 547353835.8
Gr9_im_7_3 0 s7 x9_im_a3 0 -297730651.3
Gr10_re_7_3 0 s7 x10_re_a3 0 637127669.7
Gr10_im_7_3 0 s7 x10_im_a3 0 -1394800095
Gd7_4 0 s7 p4 0 0.003211058698
Fd7_4 0 s7 V4 0.1605529349
Gr1_7_4 0 s7 x1_a4 0 -5.749471286e+10
Gr2_re_7_4 0 s7 x2_re_a4 0 4.478564201e+10
Gr2_im_7_4 0 s7 x2_im_a4 0 -9.599536155e+10
Gr3_re_7_4 0 s7 x3_re_a4 0 -1.42398349e+11
Gr3_im_7_4 0 s7 x3_im_a4 0 -1.413350681e+11
Gr4_re_7_4 0 s7 x4_re_a4 0 1734587989
Gr4_im_7_4 0 s7 x4_im_a4 0 -1000852579
Gr5_re_7_4 0 s7 x5_re_a4 0 -1059100800
Gr5_im_7_4 0 s7 x5_im_a4 0 -6059290186
Gr6_re_7_4 0 s7 x6_re_a4 0 2.007882338e+10
Gr6_im_7_4 0 s7 x6_im_a4 0 2.751131263e+10
Gr7_re_7_4 0 s7 x7_re_a4 0 -9792019980
Gr7_im_7_4 0 s7 x7_im_a4 0 -3.174669083e+10
Gr8_re_7_4 0 s7 x8_re_a4 0 -320370813.4
Gr8_im_7_4 0 s7 x8_im_a4 0 -902570337.4
Gr9_re_7_4 0 s7 x9_re_a4 0 764748616.4
Gr9_im_7_4 0 s7 x9_im_a4 0 -188018269.7
Gr10_re_7_4 0 s7 x10_re_a4 0 715681749.9
Gr10_im_7_4 0 s7 x10_im_a4 0 -950309049.9
Gd7_5 0 s7 p5 0 0.00478918731
Fd7_5 0 s7 V5 0.2394593655
Gr1_7_5 0 s7 x1_a5 0 -1.816471619e+11
Gr2_re_7_5 0 s7 x2_re_a5 0 4.434983993e+10
Gr2_im_7_5 0 s7 x2_im_a5 0 -1.401954245e+11
Gr3_re_7_5 0 s7 x3_re_a5 0 -1.216152218e+11
Gr3_im_7_5 0 s7 x3_im_a5 0 -2.573063995e+11
Gr4_re_7_5 0 s7 x4_re_a5 0 -438698498.1
Gr4_im_7_5 0 s7 x4_im_a5 0 1628737919
Gr5_re_7_5 0 s7 x5_re_a5 0 4654730572
Gr5_im_7_5 0 s7 x5_im_a5 0 -3132736776
Gr6_re_7_5 0 s7 x6_re_a5 0 -2.361681042e+10
Gr6_im_7_5 0 s7 x6_im_a5 0 2.795588716e+10
Gr7_re_7_5 0 s7 x7_re_a5 0 1.905562479e+10
Gr7_im_7_5 0 s7 x7_im_a5 0 -1.003369553e+10
Gr8_re_7_5 0 s7 x8_re_a5 0 1459385005
Gr8_im_7_5 0 s7 x8_im_a5 0 -106952519.7
Gr9_re_7_5 0 s7 x9_re_a5 0 341497938.4
Gr9_im_7_5 0 s7 x9_im_a5 0 1104356676
Gr10_re_7_5 0 s7 x10_re_a5 0 1277222078
Gr10_im_7_5 0 s7 x10_im_a5 0 1481324792
Gd7_6 0 s7 p6 0 -0.000160067062
Fd7_6 0 s7 V6 -0.008003353102
Gr1_7_6 0 s7 x1_a6 0 -6.05388383e+10
Gr2_re_7_6 0 s7 x2_re_a6 0 3.360095943e+10
Gr2_im_7_6 0 s7 x2_im_a6 0 9.381024206e+10
Gr3_re_7_6 0 s7 x3_re_a6 0 -3.993154644e+10
Gr3_im_7_6 0 s7 x3_im_a6 0 -1.579221026e+11
Gr4_re_7_6 0 s7 x4_re_a6 0 3035997744
Gr4_im_7_6 0 s7 x4_im_a6 0 -1639430076
Gr5_re_7_6 0 s7 x5_re_a6 0 -819081043.6
Gr5_im_7_6 0 s7 x5_im_a6 0 1127092807
Gr6_re_7_6 0 s7 x6_re_a6 0 6.336330454e+10
Gr6_im_7_6 0 s7 x6_im_a6 0 1.428318189e+10
Gr7_re_7_6 0 s7 x7_re_a6 0 -5129809588
Gr7_im_7_6 0 s7 x7_im_a6 0 -3.797751558e+10
Gr8_re_7_6 0 s7 x8_re_a6 0 -1681706748
Gr8_im_7_6 0 s7 x8_im_a6 0 -929637277.8
Gr9_re_7_6 0 s7 x9_re_a6 0 1065730749
Gr9_im_7_6 0 s7 x9_im_a6 0 -576584873.4
Gr10_re_7_6 0 s7 x10_re_a6 0 627429065.7
Gr10_im_7_6 0 s7 x10_im_a6 0 -2344019283
Gd7_7 0 s7 p7 0 -0.003207416208
Fd7_7 0 s7 V7 -0.1603708104
Gr1_7_7 0 s7 x1_a7 0 1.026716498e+11
Gr2_re_7_7 0 s7 x2_re_a7 0 -4.36081093e+10
Gr2_im_7_7 0 s7 x2_im_a7 0 -1.107724471e+11
Gr3_re_7_7 0 s7 x3_re_a7 0 -2.139385577e+10
Gr3_im_7_7 0 s7 x3_im_a7 0 1.948506179e+11
Gr4_re_7_7 0 s7 x4_re_a7 0 -145780349.8
Gr4_im_7_7 0 s7 x4_im_a7 0 -508592888.3
Gr5_re_7_7 0 s7 x5_re_a7 0 2917899998
Gr5_im_7_7 0 s7 x5_im_a7 0 -7082728261
Gr6_re_7_7 0 s7 x6_re_a7 0 -5.844146832e+10
Gr6_im_7_7 0 s7 x6_im_a7 0 -2.877601109e+10
Gr7_re_7_7 0 s7 x7_re_a7 0 -1.395167189e+10
Gr7_im_7_7 0 s7 x7_im_a7 0 3.17984407e+10
Gr8_re_7_7 0 s7 x8_re_a7 0 1198509458
Gr8_im_7_7 0 s7 x8_im_a7 0 684487002
Gr9_re_7_7 0 s7 x9_re_a7 0 -408439036.2
Gr9_im_7_7 0 s7 x9_im_a7 0 576069497.8
Gr10_re_7_7 0 s7 x10_re_a7 0 -166389446.2
Gr10_im_7_7 0 s7 x10_im_a7 0 1669989358
Cx1_a7 x1_a7 0 0.002631481677
Gx1_a7 0 x1_a7 p7 0 0.0001860738539
Fx1_a7 0 x1_a7 V7 0.009303692693
Rp1_a7 0 x1_a7 1e-09
Cx2_re_a7 x2_re_a7 0 0.002139679567
Gx2_re_a7 0 x2_re_a7 p7 0 0.0003025963863
Fx2_re_a7 0 x2_re_a7 V7 0.01512981932
Rp2_re_re_a7 0 x2_re_a7 1e-09
Gp2_re_im_a7 0 x2_re_a7 x2_im_a7 0 3229635754
Cx2_im_a7 x2_im_a7 0 0.002139679567
Gp2_im_re_a7 0 x2_im_a7 x2_re_a7 0 -3229635754
Rp2_im_im_a7 0 x2_im_a7 1e-09
Cx3_re_a7 x3_re_a7 0 0.002091274299
Gx3_re_a7 0 x3_re_a7 p7 0 0.0002957508476
Fx3_re_a7 0 x3_re_a7 V7 0.01478754238
Rp3_re_re_a7 0 x3_re_a7 1e-09
Gp3_re_im_a7 0 x3_re_a7 x3_im_a7 0 1009553277
Cx3_im_a7 x3_im_a7 0 0.002091274299
Gp3_im_re_a7 0 x3_im_a7 x3_re_a7 0 -1009553277
Rp3_im_im_a7 0 x3_im_a7 1e-09
Cx4_re_a7 x4_re_a7 0 0.01454723191
Gx4_re_a7 0 x4_re_a7 p7 0 0.002057289267
Fx4_re_a7 0 x4_re_a7 V7 0.1028644633
Rp4_re_re_a7 0 x4_re_a7 1e-09
Gp4_re_im_a7 0 x4_re_a7 x4_im_a7 0 1.951471624e+10
Cx4_im_a7 x4_im_a7 0 0.01454723191
Gp4_im_re_a7 0 x4_im_a7 x4_re_a7 0 -1.951471624e+10
Rp4_im_im_a7 0 x4_im_a7 1e-09
Cx5_re_a7 x5_re_a7 0 0.01007230363
Gx5_re_a7 0 x5_re_a7 p7 0 0.00142443884
Fx5_re_a7 0 x5_re_a7 V7 0.07122194198
Rp5_re_re_a7 0 x5_re_a7 1e-09
Gp5_re_im_a7 0 x5_re_a7 x5_im_a7 0 1.183679285e+10
Cx5_im_a7 x5_im_a7 0 0.01007230363
Gp5_im_re_a7 0 x5_im_a7 x5_re_a7 0 -1.183679285e+10
Rp5_im_im_a7 0 x5_im_a7 1e-09
Cx6_re_a7 x6_re_a7 0 0.004969238773
Gx6_re_a7 0 x6_re_a7 p7 0 0.0007027564868
Fx6_re_a7 0 x6_re_a7 V7 0.03513782434
Rp6_re_re_a7 0 x6_re_a7 1e-09
Gp6_re_im_a7 0 x6_re_a7 x6_im_a7 0 5205754834
Cx6_im_a7 x6_im_a7 0 0.004969238773
Gp6_im_re_a7 0 x6_im_a7 x6_re_a7 0 -5205754834
Rp6_im_im_a7 0 x6_im_a7 1e-09
Cx7_re_a7 x7_re_a7 0 0.007093124953
Gx7_re_a7 0 x7_re_a7 p7 0 0.001003119351
Fx7_re_a7 0 x7_re_a7 V7 0.05015596754
Rp7_re_re_a7 0 x7_re_a7 1e-09
Gp7_re_im_a7 0 x7_re_a7 x7_im_a7 0 6261898191
Cx7_im_a7 x7_im_a7 0 0.007093124953
Gp7_im_re_a7 0 x7_im_a7 x7_re_a7 0 -6261898191
Rp7_im_im_a7 0 x7_im_a7 1e-09
Cx8_re_a7 x8_re_a7 0 0.02175510083
Gx8_re_a7 0 x8_re_a7 p7 0 0.003076635864
Fx8_re_a7 0 x8_re_a7 V7 0.1538317932
Rp8_re_re_a7 0 x8_re_a7 1e-09
Gp8_re_im_a7 0 x8_re_a7 x8_im_a7 0 2.327097802e+10
Cx8_im_a7 x8_im_a7 0 0.02175510083
Gp8_im_re_a7 0 x8_im_a7 x8_re_a7 0 -2.327097802e+10
Rp8_im_im_a7 0 x8_im_a7 1e-09
Cx9_re_a7 x9_re_a7 0 0.02772087825
Gx9_re_a7 0 x9_re_a7 p7 0 0.003920324198
Fx9_re_a7 0 x9_re_a7 V7 0.1960162099
Rp9_re_re_a7 0 x9_re_a7 1e-09
Gp9_re_im_a7 0 x9_re_a7 x9_im_a7 0 2.583815977e+10
Cx9_im_a7 x9_im_a7 0 0.02772087825
Gp9_im_re_a7 0 x9_im_a7 x9_re_a7 0 -2.583815977e+10
Rp9_im_im_a7 0 x9_im_a7 1e-09
Cx10_re_a7 x10_re_a7 0 0.02248079784
Gx10_re_a7 0 x10_re_a7 p7 0 0.00317926492
Fx10_re_a7 0 x10_re_a7 V7 0.158963246
Rp10_re_re_a7 0 x10_re_a7 1e-09
Gp10_re_im_a7 0 x10_re_a7 x10_im_a7 0 2.233186075e+10
Cx10_im_a7 x10_im_a7 0 0.02248079784
Gp10_im_re_a7 0 x10_im_a7 x10_re_a7 0 -2.233186075e+10
Rp10_im_im_a7 0 x10_im_a7 1e-09
.ENDS seven_port
