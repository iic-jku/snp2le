* bpf_le - lumped-element equivalent (ngspice / SPICE3)
* generated by snp2le
* PDK: IHP SG13G2 (ihp-sg13g2) - IHP
* EQUIVALENT CIRCUIT FOR VECTOR FITTED S-MATRIX
* Created using scikit-rf vectorFitting.py
*
*
.SUBCKT bpf_le p1 p2
V1 p1 s1 0
R1 s1 0 50
Gd1_1 0 s1 p1 0 0.003960464722
Fd1_1 0 s1 V1 0.1980232361
Gr1_1_1 0 s1 x1_a1 0 2.082695105e+11
Gr2_re_1_1 0 s1 x2_re_a1 0 -2.33338908e+11
Gr2_im_1_1 0 s1 x2_im_a1 0 3.26752737e+11
Gr3_re_1_1 0 s1 x3_re_a1 0 4.522640152e+10
Gr3_im_1_1 0 s1 x3_im_a1 0 -1.937163788e+10
Gr4_re_1_1 0 s1 x4_re_a1 0 148295969.8
Gr4_im_1_1 0 s1 x4_im_a1 0 -3111314667
Gr5_re_1_1 0 s1 x5_re_a1 0 1771027881
Gr5_im_1_1 0 s1 x5_im_a1 0 -681918017.1
Gr6_re_1_1 0 s1 x6_re_a1 0 2563035794
Gr6_im_1_1 0 s1 x6_im_a1 0 -2142800459
Gd1_2 0 s1 p2 0 -0.001354254079
Fd1_2 0 s1 V2 -0.06771270396
Gr1_1_2 0 s1 x1_a2 0 2189814539
Gr2_re_1_2 0 s1 x2_re_a2 0 2.842816227e+10
Gr2_im_1_2 0 s1 x2_im_a2 0 8430233676
Gr3_re_1_2 0 s1 x3_re_a2 0 -3141133544
Gr3_im_1_2 0 s1 x3_im_a2 0 -1779515706
Gr4_re_1_2 0 s1 x4_re_a2 0 -629150258.3
Gr4_im_1_2 0 s1 x4_im_a2 0 4488498078
Gr5_re_1_2 0 s1 x5_re_a2 0 -1156505963
Gr5_im_1_2 0 s1 x5_im_a2 0 1280551828
Gr6_re_1_2 0 s1 x6_re_a2 0 2580922459
Gr6_im_1_2 0 s1 x6_im_a2 0 -3608044630
Cx1_a1 x1_a1 0 1
Gx1_a1 0 x1_a1 p1 0 0.07071067812
Fx1_a1 0 x1_a1 V1 3.535533906
Rp1_a1 0 x1_a1 3.291618635e-12
Cx2_re_a1 x2_re_a1 0 1
Gx2_re_a1 0 x2_re_a1 p1 0 0.1414213562
Fx2_re_a1 0 x2_re_a1 V1 7.071067812
Rp2_re_re_a1 0 x2_re_a1 1.054825213e-12
Gp2_re_im_a1 0 x2_re_a1 x2_im_a1 0 1.258345009e+12
Cx2_im_a1 x2_im_a1 0 1
Gp2_im_re_a1 0 x2_im_a1 x2_re_a1 0 -1.258345009e+12
Rp2_im_im_a1 0 x2_im_a1 1.054825213e-12
Cx3_re_a1 x3_re_a1 0 1
Gx3_re_a1 0 x3_re_a1 p1 0 0.1414213562
Fx3_re_a1 0 x3_re_a1 V1 7.071067812
Rp3_re_re_a1 0 x3_re_a1 1.017211586e-11
Gp3_re_im_a1 0 x3_re_a1 x3_im_a1 0 1.182074216e+12
Cx3_im_a1 x3_im_a1 0 1
Gp3_im_re_a1 0 x3_im_a1 x3_re_a1 0 -1.182074216e+12
Rp3_im_im_a1 0 x3_im_a1 1.017211586e-11
Cx4_re_a1 x4_re_a1 0 1
Gx4_re_a1 0 x4_re_a1 p1 0 0.1414213562
Fx4_re_a1 0 x4_re_a1 V1 7.071067812
Rp4_re_re_a1 0 x4_re_a1 2.77441115e-11
Gp4_re_im_a1 0 x4_re_a1 x4_im_a1 0 1.069181434e+12
Cx4_im_a1 x4_im_a1 0 1
Gp4_im_re_a1 0 x4_im_a1 x4_re_a1 0 -1.069181434e+12
Rp4_im_im_a1 0 x4_im_a1 2.77441115e-11
Cx5_re_a1 x5_re_a1 0 1
Gx5_re_a1 0 x5_re_a1 p1 0 0.1414213562
Fx5_re_a1 0 x5_re_a1 V1 7.071067812
Rp5_re_re_a1 0 x5_re_a1 3.856352281e-11
Gp5_re_im_a1 0 x5_re_a1 x5_im_a1 0 9.261676743e+11
Cx5_im_a1 x5_im_a1 0 1
Gp5_im_re_a1 0 x5_im_a1 x5_re_a1 0 -9.261676743e+11
Rp5_im_im_a1 0 x5_im_a1 3.856352281e-11
Cx6_re_a1 x6_re_a1 0 1
Gx6_re_a1 0 x6_re_a1 p1 0 0.1414213562
Fx6_re_a1 0 x6_re_a1 V1 7.071067812
Rp6_re_re_a1 0 x6_re_a1 2.828273957e-11
Gp6_re_im_a1 0 x6_re_a1 x6_im_a1 0 9.898928851e+11
Cx6_im_a1 x6_im_a1 0 1
Gp6_im_re_a1 0 x6_im_a1 x6_re_a1 0 -9.898928851e+11
Rp6_im_im_a1 0 x6_im_a1 2.828273957e-11
V2 p2 s2 0
R2 s2 0 50
Gd2_1 0 s2 p1 0 -0.001354254079
Fd2_1 0 s2 V1 -0.06771270396
Gr1_2_1 0 s2 x1_a1 0 2189814539
Gr2_re_2_1 0 s2 x2_re_a1 0 2.842816227e+10
Gr2_im_2_1 0 s2 x2_im_a1 0 8430233676
Gr3_re_2_1 0 s2 x3_re_a1 0 -3141133544
Gr3_im_2_1 0 s2 x3_im_a1 0 -1779515706
Gr4_re_2_1 0 s2 x4_re_a1 0 -629150258.3
Gr4_im_2_1 0 s2 x4_im_a1 0 4488498078
Gr5_re_2_1 0 s2 x5_re_a1 0 -1156505963
Gr5_im_2_1 0 s2 x5_im_a1 0 1280551828
Gr6_re_2_1 0 s2 x6_re_a1 0 2580922459
Gr6_im_2_1 0 s2 x6_im_a1 0 -3608044630
Gd2_2 0 s2 p2 0 0.003695346842
Fd2_2 0 s2 V2 0.1847673421
Gr1_2_2 0 s2 x1_a2 0 2.087755904e+11
Gr2_re_2_2 0 s2 x2_re_a2 0 -2.270584342e+11
Gr2_im_2_2 0 s2 x2_im_a2 0 3.297566647e+11
Gr3_re_2_2 0 s2 x3_re_a2 0 4.469480015e+10
Gr3_im_2_2 0 s2 x3_im_a2 0 -1.990869701e+10
Gr4_re_2_2 0 s2 x4_re_a2 0 34619831.15
Gr4_im_2_2 0 s2 x4_im_a2 0 -3033779650
Gr5_re_2_2 0 s2 x5_re_a2 0 1790808073
Gr5_im_2_2 0 s2 x5_im_a2 0 -621359955.9
Gr6_re_2_2 0 s2 x6_re_a2 0 2492840832
Gr6_im_2_2 0 s2 x6_im_a2 0 -2037762189
Cx1_a2 x1_a2 0 1
Gx1_a2 0 x1_a2 p2 0 0.07071067812
Fx1_a2 0 x1_a2 V2 3.535533906
Rp1_a2 0 x1_a2 3.291618635e-12
Cx2_re_a2 x2_re_a2 0 1
Gx2_re_a2 0 x2_re_a2 p2 0 0.1414213562
Fx2_re_a2 0 x2_re_a2 V2 7.071067812
Rp2_re_re_a2 0 x2_re_a2 1.054825213e-12
Gp2_re_im_a2 0 x2_re_a2 x2_im_a2 0 1.258345009e+12
Cx2_im_a2 x2_im_a2 0 1
Gp2_im_re_a2 0 x2_im_a2 x2_re_a2 0 -1.258345009e+12
Rp2_im_im_a2 0 x2_im_a2 1.054825213e-12
Cx3_re_a2 x3_re_a2 0 1
Gx3_re_a2 0 x3_re_a2 p2 0 0.1414213562
Fx3_re_a2 0 x3_re_a2 V2 7.071067812
Rp3_re_re_a2 0 x3_re_a2 1.017211586e-11
Gp3_re_im_a2 0 x3_re_a2 x3_im_a2 0 1.182074216e+12
Cx3_im_a2 x3_im_a2 0 1
Gp3_im_re_a2 0 x3_im_a2 x3_re_a2 0 -1.182074216e+12
Rp3_im_im_a2 0 x3_im_a2 1.017211586e-11
Cx4_re_a2 x4_re_a2 0 1
Gx4_re_a2 0 x4_re_a2 p2 0 0.1414213562
Fx4_re_a2 0 x4_re_a2 V2 7.071067812
Rp4_re_re_a2 0 x4_re_a2 2.77441115e-11
Gp4_re_im_a2 0 x4_re_a2 x4_im_a2 0 1.069181434e+12
Cx4_im_a2 x4_im_a2 0 1
Gp4_im_re_a2 0 x4_im_a2 x4_re_a2 0 -1.069181434e+12
Rp4_im_im_a2 0 x4_im_a2 2.77441115e-11
Cx5_re_a2 x5_re_a2 0 1
Gx5_re_a2 0 x5_re_a2 p2 0 0.1414213562
Fx5_re_a2 0 x5_re_a2 V2 7.071067812
Rp5_re_re_a2 0 x5_re_a2 3.856352281e-11
Gp5_re_im_a2 0 x5_re_a2 x5_im_a2 0 9.261676743e+11
Cx5_im_a2 x5_im_a2 0 1
Gp5_im_re_a2 0 x5_im_a2 x5_re_a2 0 -9.261676743e+11
Rp5_im_im_a2 0 x5_im_a2 3.856352281e-11
Cx6_re_a2 x6_re_a2 0 1
Gx6_re_a2 0 x6_re_a2 p2 0 0.1414213562
Fx6_re_a2 0 x6_re_a2 V2 7.071067812
Rp6_re_re_a2 0 x6_re_a2 2.828273957e-11
Gp6_re_im_a2 0 x6_re_a2 x6_im_a2 0 9.898928851e+11
Cx6_im_a2 x6_im_a2 0 1
Gp6_im_re_a2 0 x6_im_a2 x6_re_a2 0 -9.898928851e+11
Rp6_im_im_a2 0 x6_im_a2 2.828273957e-11
.ENDS bpf_le
