* three_port - lumped-element equivalent (ngspice / SPICE3)
* generated by snp2le
* EQUIVALENT CIRCUIT FOR VECTOR FITTED S-MATRIX
* Created using scikit-rf vectorFitting.py
*
*
.SUBCKT three_port p1 p2 p3
V1 p1 s1 0
R1 s1 0 50
Gd1_1 0 s1 p1 0 0.0004878882282
Fd1_1 0 s1 V1 0.02439441141
Gr1_1_1 0 s1 x1_a1 0 -3.25887857e+10
Gr2_re_1_1 0 s1 x2_re_a1 0 -1.828672057e+11
Gr2_im_1_1 0 s1 x2_im_a1 0 -1.239277569e+11
Gr3_re_1_1 0 s1 x3_re_a1 0 -47658794.82
Gr3_im_1_1 0 s1 x3_im_a1 0 -48654425.23
Gr4_re_1_1 0 s1 x4_re_a1 0 8.616574336e+10
Gr4_im_1_1 0 s1 x4_im_a1 0 1.415733438e+11
Gd1_2 0 s1 p2 0 0.004657826786
Fd1_2 0 s1 V2 0.2328913393
Gr1_1_2 0 s1 x1_a2 0 1.49263344e+10
Gr2_re_1_2 0 s1 x2_re_a2 0 -2.581763677e+11
Gr2_im_1_2 0 s1 x2_im_a2 0 -6.560476459e+10
Gr3_re_1_2 0 s1 x3_re_a2 0 2524334.53
Gr3_im_1_2 0 s1 x3_im_a2 0 -31716568.98
Gr4_re_1_2 0 s1 x4_re_a2 0 4.999295501e+10
Gr4_im_1_2 0 s1 x4_im_a2 0 -1.19224972e+11
Gd1_3 0 s1 p3 0 0.004649998942
Fd1_3 0 s1 V3 0.2324999471
Gr1_1_3 0 s1 x1_a3 0 1.478150141e+10
Gr2_re_1_3 0 s1 x2_re_a3 0 -2.580916278e+11
Gr2_im_1_3 0 s1 x2_im_a3 0 -6.512910196e+10
Gr3_re_1_3 0 s1 x3_re_a3 0 4967365.923
Gr3_im_1_3 0 s1 x3_im_a3 0 -27365867.45
Gr4_re_1_3 0 s1 x4_re_a3 0 5.028535336e+10
Gr4_im_1_3 0 s1 x4_im_a3 0 -1.195563184e+11
Cx1_a1 x1_a1 0 0.001640137199
Gx1_a1 0 x1_a1 p1 0 0.0001159752135
Fx1_a1 0 x1_a1 V1 0.005798760677
Rp1_a1 0 x1_a1 1e-09
Cx2_re_a1 x2_re_a1 0 0.0009144393963
Gx2_re_a1 0 x2_re_a1 p1 0 0.0001293212596
Fx2_re_a1 0 x2_re_a1 V1 0.006466062981
Rp2_re_re_a1 0 x2_re_a1 1e-09
Gp2_re_im_a1 0 x2_re_a1 x2_im_a1 0 1490443504
Cx2_im_a1 x2_im_a1 0 0.0009144393963
Gp2_im_re_a1 0 x2_im_a1 x2_re_a1 0 -1490443504
Rp2_im_im_a1 0 x2_im_a1 1e-09
Cx3_re_a1 x3_re_a1 0 0.009616996605
Gx3_re_a1 0 x3_re_a1 p1 0 0.001360048703
Fx3_re_a1 0 x3_re_a1 V1 0.06800243514
Rp3_re_re_a1 0 x3_re_a1 1e-09
Gp3_re_im_a1 0 x3_re_a1 x3_im_a1 0 1.2423396e+10
Cx3_im_a1 x3_im_a1 0 0.009616996605
Gp3_im_re_a1 0 x3_im_a1 x3_re_a1 0 -1.2423396e+10
Rp3_im_im_a1 0 x3_im_a1 1e-09
Cx4_re_a1 x4_re_a1 0 0.001058371315
Gx4_re_a1 0 x4_re_a1 p1 0 0.0001496763068
Fx4_re_a1 0 x4_re_a1 V1 0.00748381534
Rp4_re_re_a1 0 x4_re_a1 1e-09
Gp4_re_im_a1 0 x4_re_a1 x4_im_a1 0 851426554.6
Cx4_im_a1 x4_im_a1 0 0.001058371315
Gp4_im_re_a1 0 x4_im_a1 x4_re_a1 0 -851426554.6
Rp4_im_im_a1 0 x4_im_a1 1e-09
V2 p2 s2 0
R2 s2 0 50
Gd2_1 0 s2 p1 0 0.004657826786
Fd2_1 0 s2 V1 0.2328913393
Gr1_2_1 0 s2 x1_a1 0 1.49263344e+10
Gr2_re_2_1 0 s2 x2_re_a1 0 -2.581763677e+11
Gr2_im_2_1 0 s2 x2_im_a1 0 -6.560476459e+10
Gr3_re_2_1 0 s2 x3_re_a1 0 2524334.53
Gr3_im_2_1 0 s2 x3_im_a1 0 -31716568.98
Gr4_re_2_1 0 s2 x4_re_a1 0 4.999295501e+10
Gr4_im_2_1 0 s2 x4_im_a1 0 -1.19224972e+11
Gd2_2 0 s2 p2 0 0.009815231561
Fd2_2 0 s2 V2 0.490761578
Gr1_2_2 0 s2 x1_a2 0 -2.979725375e+11
Gr2_re_2_2 0 s2 x2_re_a2 0 -2.630156008e+10
Gr2_im_2_2 0 s2 x2_im_a2 0 -4.394626229e+11
Gr3_re_2_2 0 s2 x3_re_a2 0 -797008023
Gr3_im_2_2 0 s2 x3_im_a2 0 39958054.87
Gr4_re_2_2 0 s2 x4_re_a2 0 -1.465045338e+11
Gr4_im_2_2 0 s2 x4_im_a2 0 -9.978071102e+10
Gd2_3 0 s2 p3 0 -0.009906767219
Fd2_3 0 s2 V3 -0.495338361
Gr1_2_3 0 s2 x1_a3 0 3.081729552e+11
Gr2_re_2_3 0 s2 x2_re_a3 0 2.005653837e+11
Gr2_im_2_3 0 s2 x2_im_a3 0 5.440920567e+11
Gr3_re_2_3 0 s2 x3_re_a3 0 770270151.2
Gr3_im_2_3 0 s2 x3_im_a3 0 -48091646.74
Gr4_re_2_3 0 s2 x4_re_a3 0 7.224849773e+10
Gr4_im_2_3 0 s2 x4_im_a3 0 -5.590654758e+10
Cx1_a2 x1_a2 0 0.001640137199
Gx1_a2 0 x1_a2 p2 0 0.0001159752135
Fx1_a2 0 x1_a2 V2 0.005798760677
Rp1_a2 0 x1_a2 1e-09
Cx2_re_a2 x2_re_a2 0 0.0009144393963
Gx2_re_a2 0 x2_re_a2 p2 0 0.0001293212596
Fx2_re_a2 0 x2_re_a2 V2 0.006466062981
Rp2_re_re_a2 0 x2_re_a2 1e-09
Gp2_re_im_a2 0 x2_re_a2 x2_im_a2 0 1490443504
Cx2_im_a2 x2_im_a2 0 0.0009144393963
Gp2_im_re_a2 0 x2_im_a2 x2_re_a2 0 -1490443504
Rp2_im_im_a2 0 x2_im_a2 1e-09
Cx3_re_a2 x3_re_a2 0 0.009616996605
Gx3_re_a2 0 x3_re_a2 p2 0 0.001360048703
Fx3_re_a2 0 x3_re_a2 V2 0.06800243514
Rp3_re_re_a2 0 x3_re_a2 1e-09
Gp3_re_im_a2 0 x3_re_a2 x3_im_a2 0 1.2423396e+10
Cx3_im_a2 x3_im_a2 0 0.009616996605
Gp3_im_re_a2 0 x3_im_a2 x3_re_a2 0 -1.2423396e+10
Rp3_im_im_a2 0 x3_im_a2 1e-09
Cx4_re_a2 x4_re_a2 0 0.001058371315
Gx4_re_a2 0 x4_re_a2 p2 0 0.0001496763068
Fx4_re_a2 0 x4_re_a2 V2 0.00748381534
Rp4_re_re_a2 0 x4_re_a2 1e-09
Gp4_re_im_a2 0 x4_re_a2 x4_im_a2 0 851426554.6
Cx4_im_a2 x4_im_a2 0 0.001058371315
Gp4_im_re_a2 0 x4_im_a2 x4_re_a2 0 -851426554.6
Rp4_im_im_a2 0 x4_im_a2 1e-09
V3 p3 s3 0
R3 s3 0 50
Gd3_1 0 s3 p1 0 0.004649998943
Fd3_1 0 s3 V1 0.2324999471
Gr1_3_1 0 s3 x1_a1 0 1.478150141e+10
Gr2_re_3_1 0 s3 x2_re_a1 0 -2.580916278e+11
Gr2_im_3_1 0 s3 x2_im_a1 0 -6.512910196e+10
Gr3_re_3_1 0 s3 x3_re_a1 0 4967365.923
Gr3_im_3_1 0 s3 x3_im_a1 0 -27365867.45
Gr4_re_3_1 0 s3 x4_re_a1 0 5.028535336e+10
Gr4_im_3_1 0 s3 x4_im_a1 0 -1.195563184e+11
Gd3_2 0 s3 p2 0 -0.009906767219
Fd3_2 0 s3 V2 -0.495338361
Gr1_3_2 0 s3 x1_a2 0 3.081729552e+11
Gr2_re_3_2 0 s3 x2_re_a2 0 2.005653837e+11
Gr2_im_3_2 0 s3 x2_im_a2 0 5.440920567e+11
Gr3_re_3_2 0 s3 x3_re_a2 0 770270151.2
Gr3_im_3_2 0 s3 x3_im_a2 0 -48091646.74
Gr4_re_3_2 0 s3 x4_re_a2 0 7.224849773e+10
Gr4_im_3_2 0 s3 x4_im_a2 0 -5.590654758e+10
Gd3_3 0 s3 p3 0 0.009805339785
Fd3_3 0 s3 V3 0.4902669892
Gr1_3_3 0 s3 x1_a3 0 -2.979600944e+11
Gr2_re_3_3 0 s3 x2_re_a3 0 -2.609952483e+10
Gr2_im_3_3 0 s3 x2_im_a3 0 -4.39279062e+11
Gr3_re_3_3 0 s3 x3_re_a3 0 -803490064.2
Gr3_im_3_3 0 s3 x3_im_a3 0 37171998.34
Gr4_re_3_3 0 s3 x4_re_a3 0 -1.465849666e+11
Gr4_im_3_3 0 s3 x4_im_a3 0 -1.000385392e+11
Cx1_a3 x1_a3 0 0.001640137199
Gx1_a3 0 x1_a3 p3 0 0.0001159752135
Fx1_a3 0 x1_a3 V3 0.005798760677
Rp1_a3 0 x1_a3 1e-09
Cx2_re_a3 x2_re_a3 0 0.0009144393963
Gx2_re_a3 0 x2_re_a3 p3 0 0.0001293212596
Fx2_re_a3 0 x2_re_a3 V3 0.006466062981
Rp2_re_re_a3 0 x2_re_a3 1e-09
Gp2_re_im_a3 0 x2_re_a3 x2_im_a3 0 1490443504
Cx2_im_a3 x2_im_a3 0 0.0009144393963
Gp2_im_re_a3 0 x2_im_a3 x2_re_a3 0 -1490443504
Rp2_im_im_a3 0 x2_im_a3 1e-09
Cx3_re_a3 x3_re_a3 0 0.009616996605
Gx3_re_a3 0 x3_re_a3 p3 0 0.001360048703
Fx3_re_a3 0 x3_re_a3 V3 0.06800243514
Rp3_re_re_a3 0 x3_re_a3 1e-09
Gp3_re_im_a3 0 x3_re_a3 x3_im_a3 0 1.2423396e+10
Cx3_im_a3 x3_im_a3 0 0.009616996605
Gp3_im_re_a3 0 x3_im_a3 x3_re_a3 0 -1.2423396e+10
Rp3_im_im_a3 0 x3_im_a3 1e-09
Cx4_re_a3 x4_re_a3 0 0.001058371315
Gx4_re_a3 0 x4_re_a3 p3 0 0.0001496763068
Fx4_re_a3 0 x4_re_a3 V3 0.00748381534
Rp4_re_re_a3 0 x4_re_a3 1e-09
Gp4_re_im_a3 0 x4_re_a3 x4_im_a3 0 851426554.6
Cx4_im_a3 x4_im_a3 0 0.001058371315
Gp4_im_re_a3 0 x4_im_a3 x4_re_a3 0 -851426554.6
Rp4_im_im_a3 0 x4_im_a3 1e-09
.ENDS three_port
