* EQUIVALENT CIRCUIT FOR VECTOR FITTED S-MATRIX
* Created using scikit-rf vectorFitting.py
*
.SUBCKT ind_d20_w7_sp3_nw1_r10_fit p1 p2
*
* Port network for port 1
V1 p1 s1 0
R1 s1 0 50.0
Gd1_1 0 s1 p1 0 3.711628330181661e-06
Fd1_1 0 s1 V1 0.00018558141650908307
Gr1_1_1 0 s1 x1_a1 0 -31776326076201.707
Gr2_1_1 0 s1 x2_a1 0 31721300530794.96
Gr3_re_1_1 0 s1 x3_re_a1 0 -271757631514.52408
Gr3_im_1_1 0 s1 x3_im_a1 0 760974268627.4663
Gr4_re_1_1 0 s1 x4_re_a1 0 -173945857953.89886
Gr4_im_1_1 0 s1 x4_im_a1 0 -163695188350.17316
Gr5_re_1_1 0 s1 x5_re_a1 0 81208787.09273534
Gr5_im_1_1 0 s1 x5_im_a1 0 -120021549.11669426
Gr6_re_1_1 0 s1 x6_re_a1 0 -15178668281.482115
Gr6_im_1_1 0 s1 x6_im_a1 0 3431832375.0217166
Gr7_1_1 0 s1 x7_a1 0 -1091219733714.6892
Gr8_1_1 0 s1 x8_a1 0 -14334233989.439882
Gr9_re_1_1 0 s1 x9_re_a1 0 -25484678.023830056
Gr9_im_1_1 0 s1 x9_im_a1 0 -14275106.770229368
Gr10_1_1 0 s1 x10_a1 0 -1995928733.3686066
Gr11_1_1 0 s1 x11_a1 0 -10550955.302597424
Gr12_1_1 0 s1 x12_a1 0 -15296391.093930654
Gd1_2 0 s1 p2 0 3.434079503277232e-06
Fd1_2 0 s1 V2 0.0001717039751638616
Gr1_1_2 0 s1 x1_a2 0 -7041113653261.468
Gr2_1_2 0 s1 x2_a2 0 5423844551261.041
Gr3_re_1_2 0 s1 x3_re_a2 0 -329981856706.286
Gr3_im_1_2 0 s1 x3_im_a2 0 493850959592.1416
Gr4_re_1_2 0 s1 x4_re_a2 0 249520029358.41757
Gr4_im_1_2 0 s1 x4_im_a2 0 154327130762.8822
Gr5_re_1_2 0 s1 x5_re_a2 0 207950372.2108017
Gr5_im_1_2 0 s1 x5_im_a2 0 53940853.04245705
Gr6_re_1_2 0 s1 x6_re_a2 0 18630003277.518127
Gr6_im_1_2 0 s1 x6_im_a2 0 -10098666008.530312
Gr7_1_2 0 s1 x7_a2 0 898468936914.5707
Gr8_1_2 0 s1 x8_a2 0 33611862852.92027
Gr9_re_1_2 0 s1 x9_re_a2 0 866433.0328169053
Gr9_im_1_2 0 s1 x9_im_a2 0 -92792.22345425926
Gr10_1_2 0 s1 x10_a2 0 960473874.51772
Gr11_1_2 0 s1 x11_a2 0 153108115.80925825
Gr12_1_2 0 s1 x12_a2 0 12741420.254096784
*
* State networks driven by port 1
Cx1_a1 x1_a1 0 1.0
Gx1_a1 0 x1_a1 p1 0 0.07071067811865475
Fx1_a1 0 x1_a1 V1 3.5355339059327378
Rp1_a1 0 x1_a1 1.0748045535589735e-13
Cx2_a1 x2_a1 0 1.0
Gx2_a1 0 x2_a1 p1 0 0.07071067811865475
Fx2_a1 0 x2_a1 V1 3.5355339059327378
Rp2_a1 0 x2_a1 1.3823007184542294e-13
Cx3_re_a1 x3_re_a1 0 1.0
Gx3_re_a1 0 x3_re_a1 p1 0 0.1414213562373095
Fx3_re_a1 0 x3_re_a1 V1 7.0710678118654755
Rp3_re_re_a1 0 x3_re_a1 6.096303754632174e-13
Gp3_re_im_a1 0 x3_re_a1 x3_im_a1 0 4282981881925.2373
Cx3_im_a1 x3_im_a1 0 1.0
Gp3_im_re_a1 0 x3_im_a1 x3_re_a1 0 -4282981881925.2373
Rp3_im_im_a1 0 x3_im_a1 6.096303754632174e-13
Cx4_re_a1 x4_re_a1 0 1.0
Gx4_re_a1 0 x4_re_a1 p1 0 0.1414213562373095
Fx4_re_a1 0 x4_re_a1 V1 7.0710678118654755
Rp4_re_re_a1 0 x4_re_a1 1.182351113553967e-12
Gp4_re_im_a1 0 x4_re_a1 x4_im_a1 0 3441003597278.048
Cx4_im_a1 x4_im_a1 0 1.0
Gp4_im_re_a1 0 x4_im_a1 x4_re_a1 0 -3441003597278.048
Rp4_im_im_a1 0 x4_im_a1 1.182351113553967e-12
Cx5_re_a1 x5_re_a1 0 1.0
Gx5_re_a1 0 x5_re_a1 p1 0 0.1414213562373095
Fx5_re_a1 0 x5_re_a1 V1 7.0710678118654755
Rp5_re_re_a1 0 x5_re_a1 1.8569678222643716e-11
Gp5_re_im_a1 0 x5_re_a1 x5_im_a1 0 3119012781617.8633
Cx5_im_a1 x5_im_a1 0 1.0
Gp5_im_re_a1 0 x5_im_a1 x5_re_a1 0 -3119012781617.8633
Rp5_im_im_a1 0 x5_im_a1 1.8569678222643716e-11
Cx6_re_a1 x6_re_a1 0 1.0
Gx6_re_a1 0 x6_re_a1 p1 0 0.1414213562373095
Fx6_re_a1 0 x6_re_a1 V1 7.0710678118654755
Rp6_re_re_a1 0 x6_re_a1 1.036543938329829e-11
Gp6_re_im_a1 0 x6_re_a1 x6_im_a1 0 2500437994298.6694
Cx6_im_a1 x6_im_a1 0 1.0
Gp6_im_re_a1 0 x6_im_a1 x6_re_a1 0 -2500437994298.6694
Rp6_im_im_a1 0 x6_im_a1 1.036543938329829e-11
Cx7_a1 x7_a1 0 1.0
Gx7_a1 0 x7_a1 p1 0 0.07071067811865475
Fx7_a1 0 x7_a1 V1 3.5355339059327378
Rp7_a1 0 x7_a1 5.975263910152812e-13
Cx8_a1 x8_a1 0 1.0
Gx8_a1 0 x8_a1 p1 0 0.07071067811865475
Fx8_a1 0 x8_a1 V1 3.5355339059327378
Rp8_a1 0 x8_a1 1.1448242110347656e-12
Cx9_re_a1 x9_re_a1 0 1.0
Gx9_re_a1 0 x9_re_a1 p1 0 0.1414213562373095
Fx9_re_a1 0 x9_re_a1 V1 7.0710678118654755
Rp9_re_re_a1 0 x9_re_a1 1.6273225588771993e-11
Gp9_re_im_a1 0 x9_re_a1 x9_im_a1 0 291078249897.9499
Cx9_im_a1 x9_im_a1 0 1.0
Gp9_im_re_a1 0 x9_im_a1 x9_re_a1 0 -291078249897.9499
Rp9_im_im_a1 0 x9_im_a1 1.6273225588771993e-11
Cx10_a1 x10_a1 0 1.0
Gx10_a1 0 x10_a1 p1 0 0.07071067811865475
Fx10_a1 0 x10_a1 V1 3.5355339059327378
Rp10_a1 0 x10_a1 4.022304473839298e-12
Cx11_a1 x11_a1 0 1.0
Gx11_a1 0 x11_a1 p1 0 0.07071067811865475
Fx11_a1 0 x11_a1 V1 3.5355339059327378
Rp11_a1 0 x11_a1 1.1863611077438883e-11
Cx12_a1 x12_a1 0 1.0
Gx12_a1 0 x12_a1 p1 0 0.07071067811865475
Fx12_a1 0 x12_a1 V1 3.5355339059327378
Rp12_a1 0 x12_a1 5.439236626779881e-11
*
* Port network for port 2
V2 p2 s2 0
R2 s2 0 50.0
Gd2_1 0 s2 p1 0 3.434079503277232e-06
Fd2_1 0 s2 V1 0.0001717039751638616
Gr1_2_1 0 s2 x1_a1 0 -7041113653261.468
Gr2_2_1 0 s2 x2_a1 0 5423844551261.041
Gr3_re_2_1 0 s2 x3_re_a1 0 -329981856706.286
Gr3_im_2_1 0 s2 x3_im_a1 0 493850959592.1416
Gr4_re_2_1 0 s2 x4_re_a1 0 249520029358.41757
Gr4_im_2_1 0 s2 x4_im_a1 0 154327130762.8822
Gr5_re_2_1 0 s2 x5_re_a1 0 207950372.2108017
Gr5_im_2_1 0 s2 x5_im_a1 0 53940853.04245705
Gr6_re_2_1 0 s2 x6_re_a1 0 18630003277.518127
Gr6_im_2_1 0 s2 x6_im_a1 0 -10098666008.530312
Gr7_2_1 0 s2 x7_a1 0 898468936914.5707
Gr8_2_1 0 s2 x8_a1 0 33611862852.92027
Gr9_re_2_1 0 s2 x9_re_a1 0 866433.0328169053
Gr9_im_2_1 0 s2 x9_im_a1 0 -92792.22345425926
Gr10_2_1 0 s2 x10_a1 0 960473874.51772
Gr11_2_1 0 s2 x11_a1 0 153108115.80925825
Gr12_2_1 0 s2 x12_a1 0 12741420.254096784
Gd2_2 0 s2 p2 0 2.29870265702925e-06
Fd2_2 0 s2 V2 0.00011493513285146251
Gr1_2_2 0 s2 x1_a2 0 -14154523712522.658
Gr2_2_2 0 s2 x2_a2 0 15183215479282.848
Gr3_re_2_2 0 s2 x3_re_a2 0 374264818236.3534
Gr3_im_2_2 0 s2 x3_im_a2 0 -85091877658.58936
Gr4_re_2_2 0 s2 x4_re_a2 0 -614954239473.7098
Gr4_im_2_2 0 s2 x4_im_a2 0 -37678088609.0676
Gr5_re_2_2 0 s2 x5_re_a2 0 493978065.10917944
Gr5_im_2_2 0 s2 x5_im_a2 0 567061572.1739447
Gr6_re_2_2 0 s2 x6_re_a2 0 -20815977141.936565
Gr6_im_2_2 0 s2 x6_im_a2 0 20132281871.5015
Gr7_2_2 0 s2 x7_a2 0 -927163886057.1816
Gr8_2_2 0 s2 x8_a2 0 -23374544659.991806
Gr9_re_2_2 0 s2 x9_re_a2 0 -10862402.427861014
Gr9_im_2_2 0 s2 x9_im_a2 0 -6826131.305558256
Gr10_2_2 0 s2 x10_a2 0 -1466342421.465599
Gr11_2_2 0 s2 x11_a2 0 -81703611.6971528
Gr12_2_2 0 s2 x12_a2 0 -10206475.315431388
*
* State networks driven by port 2
Cx1_a2 x1_a2 0 1.0
Gx1_a2 0 x1_a2 p2 0 0.07071067811865475
Fx1_a2 0 x1_a2 V2 3.5355339059327378
Rp1_a2 0 x1_a2 1.0748045535589735e-13
Cx2_a2 x2_a2 0 1.0
Gx2_a2 0 x2_a2 p2 0 0.07071067811865475
Fx2_a2 0 x2_a2 V2 3.5355339059327378
Rp2_a2 0 x2_a2 1.3823007184542294e-13
Cx3_re_a2 x3_re_a2 0 1.0
Gx3_re_a2 0 x3_re_a2 p2 0 0.1414213562373095
Fx3_re_a2 0 x3_re_a2 V2 7.0710678118654755
Rp3_re_re_a2 0 x3_re_a2 6.096303754632174e-13
Gp3_re_im_a2 0 x3_re_a2 x3_im_a2 0 4282981881925.2373
Cx3_im_a2 x3_im_a2 0 1.0
Gp3_im_re_a2 0 x3_im_a2 x3_re_a2 0 -4282981881925.2373
Rp3_im_im_a2 0 x3_im_a2 6.096303754632174e-13
Cx4_re_a2 x4_re_a2 0 1.0
Gx4_re_a2 0 x4_re_a2 p2 0 0.1414213562373095
Fx4_re_a2 0 x4_re_a2 V2 7.0710678118654755
Rp4_re_re_a2 0 x4_re_a2 1.182351113553967e-12
Gp4_re_im_a2 0 x4_re_a2 x4_im_a2 0 3441003597278.048
Cx4_im_a2 x4_im_a2 0 1.0
Gp4_im_re_a2 0 x4_im_a2 x4_re_a2 0 -3441003597278.048
Rp4_im_im_a2 0 x4_im_a2 1.182351113553967e-12
Cx5_re_a2 x5_re_a2 0 1.0
Gx5_re_a2 0 x5_re_a2 p2 0 0.1414213562373095
Fx5_re_a2 0 x5_re_a2 V2 7.0710678118654755
Rp5_re_re_a2 0 x5_re_a2 1.8569678222643716e-11
Gp5_re_im_a2 0 x5_re_a2 x5_im_a2 0 3119012781617.8633
Cx5_im_a2 x5_im_a2 0 1.0
Gp5_im_re_a2 0 x5_im_a2 x5_re_a2 0 -3119012781617.8633
Rp5_im_im_a2 0 x5_im_a2 1.8569678222643716e-11
Cx6_re_a2 x6_re_a2 0 1.0
Gx6_re_a2 0 x6_re_a2 p2 0 0.1414213562373095
Fx6_re_a2 0 x6_re_a2 V2 7.0710678118654755
Rp6_re_re_a2 0 x6_re_a2 1.036543938329829e-11
Gp6_re_im_a2 0 x6_re_a2 x6_im_a2 0 2500437994298.6694
Cx6_im_a2 x6_im_a2 0 1.0
Gp6_im_re_a2 0 x6_im_a2 x6_re_a2 0 -2500437994298.6694
Rp6_im_im_a2 0 x6_im_a2 1.036543938329829e-11
Cx7_a2 x7_a2 0 1.0
Gx7_a2 0 x7_a2 p2 0 0.07071067811865475
Fx7_a2 0 x7_a2 V2 3.5355339059327378
Rp7_a2 0 x7_a2 5.975263910152812e-13
Cx8_a2 x8_a2 0 1.0
Gx8_a2 0 x8_a2 p2 0 0.07071067811865475
Fx8_a2 0 x8_a2 V2 3.5355339059327378
Rp8_a2 0 x8_a2 1.1448242110347656e-12
Cx9_re_a2 x9_re_a2 0 1.0
Gx9_re_a2 0 x9_re_a2 p2 0 0.1414213562373095
Fx9_re_a2 0 x9_re_a2 V2 7.0710678118654755
Rp9_re_re_a2 0 x9_re_a2 1.6273225588771993e-11
Gp9_re_im_a2 0 x9_re_a2 x9_im_a2 0 291078249897.9499
Cx9_im_a2 x9_im_a2 0 1.0
Gp9_im_re_a2 0 x9_im_a2 x9_re_a2 0 -291078249897.9499
Rp9_im_im_a2 0 x9_im_a2 1.6273225588771993e-11
Cx10_a2 x10_a2 0 1.0
Gx10_a2 0 x10_a2 p2 0 0.07071067811865475
Fx10_a2 0 x10_a2 V2 3.5355339059327378
Rp10_a2 0 x10_a2 4.022304473839298e-12
Cx11_a2 x11_a2 0 1.0
Gx11_a2 0 x11_a2 p2 0 0.07071067811865475
Fx11_a2 0 x11_a2 V2 3.5355339059327378
Rp11_a2 0 x11_a2 1.1863611077438883e-11
Cx12_a2 x12_a2 0 1.0
Gx12_a2 0 x12_a2 p2 0 0.07071067811865475
Fx12_a2 0 x12_a2 V2 3.5355339059327378
Rp12_a2 0 x12_a2 5.439236626779881e-11
.ENDS ind_d20_w7_sp3_nw1_r10_fit
