* auto-generated by snp2le from the fitted frequency band, overwritten on each run
.csparam f_min=1.200000e+11
.csparam f_max=2.000000e+11
